simulator lang=spectre
// MOS D G S B; Spectre W = CDF wf = total width; CDF w = W/nf.
include "../../../logic/SAR_CAPTURE_LATCH/transistor/netlist.scs"
include "../../../logic/SAR_NAND2/transistor/netlist.scs"
include "../../../logic/SAR_DRIVE/transistor/netlist.scs"
subckt SAR_BIT (Outp Capture Sample Q Bp Bn VDD VSS VREFP VREFN)
parameters strength=1
I_latch (Outp Capture Q QB VDD VSS) SAR_CAPTURE_LATCH
I_select_p (Q Capture BpRaw VDD VSS) SAR_NAND2
I_select_n (QB Capture BnRaw VDD VSS) SAR_NAND2
I_buf_p0 (BpRaw BpBuf0 VDD VSS) SAR_DRIVE scale=max(1,strength*1)
I_buf_p1 (BpBuf0 BpBuf1 VDD VSS) SAR_DRIVE scale=max(1,strength*4)
I_buf_p2 (BpBuf1 BpBuf2 VDD VSS) SAR_DRIVE scale=max(1,strength*32)
I_buf_p3 (BpBuf2 Bp VREFP VREFN) SAR_DRIVE scale=max(2,strength*256)
I_buf_n0 (BnRaw BnBuf0 VDD VSS) SAR_DRIVE scale=max(1,strength*1)
I_buf_n1 (BnBuf0 BnBuf1 VDD VSS) SAR_DRIVE scale=max(1,strength*4)
I_buf_n2 (BnBuf1 BnBuf2 VDD VSS) SAR_DRIVE scale=max(1,strength*32)
I_buf_n3 (BnBuf2 Bn VREFP VREFN) SAR_DRIVE scale=max(2,strength*256)
ends SAR_BIT
