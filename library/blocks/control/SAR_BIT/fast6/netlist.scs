simulator lang=spectre
// MOS D G S B; Spectre W = CDF wf = total width; CDF w = W/nf.
include "../../../../support/standard_cells/DFQD1BWP7T/spectre/netlist.scs"
include "../../../logic/SAR_NAND2/transistor/netlist.scs"
include "../../../../support/standard_cells/INVD1BWP7T/spectre/netlist.scs"
include "../../../logic/SAR_DELAY2/transistor/netlist.scs"
include "../../../logic/SAR_DRIVE/transistor/netlist.scs"
subckt SAR_BIT (Outp Capture Sample Q Bp Bn VDD VSS VREFP VREFN)
parameters strength=1
I_latch (Outp Capture Q VDD VSS) DFQD1BWP7T
I_qbar (Q QB VDD VSS) INVD1BWP7T
I_capture_delay (Capture CaptureD VDD VSS) SAR_DELAY2
I_select_p (Q CaptureD BpRaw VDD VSS) SAR_NAND2
I_select_n (QB CaptureD BnRaw VDD VSS) SAR_NAND2
I_buf_p0 (BpRaw BpBuf VDD VSS) SAR_DRIVE scale=max(1,strength*8)
I_buf_p1 (BpBuf Bp VREFP VREFN) SAR_DRIVE scale=max(1,strength*64)
I_buf_n0 (BnRaw BnBuf VDD VSS) SAR_DRIVE scale=max(1,strength*8)
I_buf_n1 (BnBuf Bn VREFP VREFN) SAR_DRIVE scale=max(1,strength*64)
ends SAR_BIT
