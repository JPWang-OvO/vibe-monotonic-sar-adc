`include "constants.vams"
`include "disciplines.vams"
module SAR_BIT_va(Outp,Capture,Sample,Q,Bp,Bn,VDD,VSS,VREFP,VREFN);
input Outp,Capture,Sample,VDD,VSS,VREFP,VREFN;output Q,Bp,Bn;
electrical Outp,Capture,Sample,Q,Bp,Bn,VDD,VSS,VREFP,VREFN;
integer q,enabled;
analog begin
 @(initial_step) begin q=0;enabled=0;end
 @(cross(V(Sample,VSS)-0.9,+1)) enabled=0;
 @(cross(V(Capture,VSS)-0.9,+1)) begin q=(V(Outp,VSS)>=0.9);enabled=1;end
 V(Q,VSS)<+transition(q*1.8,0,1p,1p);
 V(Bp,VREFN)<+transition((1-enabled*q)*1.8,20p,1p,1p);
 V(Bn,VREFN)<+transition((1-enabled*(1-q))*1.8,20p,1p,1p);
end
endmodule
