simulator lang=spectre
// MOS D G S B; Spectre W = CDF wf = total width; CDF w = W/nf.
include "../../../../support/standard_cells/DFQD1BWP7T/spectre/netlist.scs"
include "../../../../support/standard_cells/ND2D1BWP7T/spectre/netlist.scs"
include "../../../../support/standard_cells/INVD1BWP7T/spectre/netlist.scs"
include "../../../logic/SAR_DELAY4/transistor/netlist.scs"
include "../../../logic/SAR_DRIVE/transistor/netlist.scs"
subckt SAR_BIT (Outp Capture Sample Q Bp Bn VDD VSS VREFP VREFN)
parameters strength=1
I_latch (Outp Capture Q VDD VSS) DFQD1BWP7T
I_qbar (Q QB VDD VSS) INVD1BWP7T
I_capture_delay (Capture CaptureD VDD VSS) SAR_DELAY4
I_select_p (Q CaptureD BpRaw VDD VSS) ND2D1BWP7T
I_select_n (QB CaptureD BnRaw VDD VSS) ND2D1BWP7T
I_buf_p0 (BpRaw BpBuf0 VDD VSS) SAR_DRIVE scale=max(1,strength*1)
I_buf_p1 (BpBuf0 BpBuf1 VDD VSS) SAR_DRIVE scale=max(1,strength*4)
I_buf_p2 (BpBuf1 BpBuf2 VDD VSS) SAR_DRIVE scale=max(1,strength*16)
I_buf_p3 (BpBuf2 Bp VREFP VREFN) SAR_DRIVE scale=max(1,strength*64)
I_buf_n0 (BnRaw BnBuf0 VDD VSS) SAR_DRIVE scale=max(1,strength*1)
I_buf_n1 (BnBuf0 BnBuf1 VDD VSS) SAR_DRIVE scale=max(1,strength*4)
I_buf_n2 (BnBuf1 BnBuf2 VDD VSS) SAR_DRIVE scale=max(1,strength*16)
I_buf_n3 (BnBuf2 Bn VREFP VREFN) SAR_DRIVE scale=max(1,strength*64)
ends SAR_BIT
