simulator lang=spectre
// MOS D G S B; Spectre W = CDF wf = total width; CDF w = W/nf.
include "../../../../support/standard_cells/DFCNQD1BWP7T/netlist/netlist.scs"
include "../../../../support/standard_cells/NR3D1BWP7T/netlist/netlist.scs"
include "../../../logic/SAR_DRIVE/netlist/netlist.scs"
include "../../../logic/SAR_DELAY/netlist/netlist.scs"
include "../../../logic/SAR_DELAY4/netlist/netlist.scs"
subckt SAR_ASYNC (Sample Valid ClkC Done Ck\<9\> Ck\<8\> Ck\<7\> Ck\<6\> Ck\<5\> Ck\<4\> Ck\<3\> Ck\<2\> Ck\<1\> Ck\<0\> VDD VSS)
I_sample_inv (Sample ClearN VDD VSS) SAR_DRIVE scale=8
I_seq0 (VDD Valid ClearN Ck\<9\> VDD VSS) DFCNQD1BWP7T
I_seq1 (Ck\<9\> Valid ClearN Ck\<8\> VDD VSS) DFCNQD1BWP7T
I_seq2 (Ck\<8\> Valid ClearN Ck\<7\> VDD VSS) DFCNQD1BWP7T
I_seq3 (Ck\<7\> Valid ClearN Ck\<6\> VDD VSS) DFCNQD1BWP7T
I_seq4 (Ck\<6\> Valid ClearN Ck\<5\> VDD VSS) DFCNQD1BWP7T
I_seq5 (Ck\<5\> Valid ClearN Ck\<4\> VDD VSS) DFCNQD1BWP7T
I_seq6 (Ck\<4\> Valid ClearN Ck\<3\> VDD VSS) DFCNQD1BWP7T
I_seq7 (Ck\<3\> Valid ClearN Ck\<2\> VDD VSS) DFCNQD1BWP7T
I_seq8 (Ck\<2\> Valid ClearN Ck\<1\> VDD VSS) DFCNQD1BWP7T
I_seq9 (Ck\<1\> Valid ClearN Ck\<0\> VDD VSS) DFCNQD1BWP7T
I_sample_guard (Sample SampleGuard VDD VSS) SAR_DELAY4
I_feedback_delay (Valid ValidDelay VDD VSS) SAR_DELAY4
I_run_nor (SampleGuard ValidDelay Ck\<0\> CompareEnable VDD VSS) NR3D1BWP7T
I_clock_drive (CompareEnable ClkC VDD VSS) SAR_DRIVE scale=1
I_done_delay (Ck\<0\> Done VDD VSS) SAR_DELAY
ends SAR_ASYNC
