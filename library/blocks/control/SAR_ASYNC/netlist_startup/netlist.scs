simulator lang=spectre
include "../../../logic/SAR_HANDSHAKE/netlist/netlist.scs"
// MOS D G S B; Spectre W = CDF wf = total width; CDF w = W/nf.
include "../../../logic/SAR_DFFR/netlist/netlist.scs"
include "../../../logic/SAR_NOR4/netlist/netlist.scs"
include "../../../logic/SAR_DRIVE/netlist/netlist.scs"
include "../../../logic/SAR_DONE_DELAY/netlist/netlist.scs"
include "../../../logic/SAR_SAMPLE_GUARD12/netlist/netlist.scs"
include "../../../logic/SAR_STARTUP/netlist/netlist.scs"
subckt SAR_ASYNC (Sample Valid ClkC Done Ck\<9\> Ck\<8\> Ck\<7\> Ck\<6\> Ck\<5\> Ck\<4\> Ck\<3\> Ck\<2\> Ck\<1\> Ck\<0\> VDD VSS)
I_startup (Sample SampleGuard Hold ClearN VDD VSS) SAR_STARTUP
I_seq0 (VDD Valid ClearN Ck\<9\> VDD VSS) SAR_DFFR
I_seq1 (Ck\<9\> Valid ClearN Ck\<8\> VDD VSS) SAR_DFFR
I_seq2 (Ck\<8\> Valid ClearN Ck\<7\> VDD VSS) SAR_DFFR
I_seq3 (Ck\<7\> Valid ClearN Ck\<6\> VDD VSS) SAR_DFFR
I_seq4 (Ck\<6\> Valid ClearN Ck\<5\> VDD VSS) SAR_DFFR
I_seq5 (Ck\<5\> Valid ClearN Ck\<4\> VDD VSS) SAR_DFFR
I_seq6 (Ck\<4\> Valid ClearN Ck\<3\> VDD VSS) SAR_DFFR
I_seq7 (Ck\<3\> Valid ClearN Ck\<2\> VDD VSS) SAR_DFFR
I_seq8 (Ck\<2\> Valid ClearN Ck\<1\> VDD VSS) SAR_DFFR
I_seq9 (Ck\<1\> Valid ClearN Ck\<0\> VDD VSS) SAR_DFFR
I_sample_guard (Sample SampleGuard VDD VSS) SAR_SAMPLE_GUARD12
I_feedback_delay (Valid ValidDelay VDD VSS) SAR_HANDSHAKE
I_run_nor (Hold Valid ValidDelay Ck\<0\> CompareEnable VDD VSS) SAR_NOR4
I_clock_drive (CompareEnable ClkC VDD VSS) SAR_DRIVE scale=4
I_done_delay (Ck\<0\> Done VDD VSS) SAR_DONE_DELAY
ends SAR_ASYNC
