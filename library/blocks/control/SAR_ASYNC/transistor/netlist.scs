simulator lang=spectre
// MOS D G S B; Spectre W = CDF wf = total width; CDF w = W/nf.
include "../../../../support/standard_cells/DFCNQD1BWP7T/spectre/netlist.scs"
include "../../../../support/standard_cells/NR3D1BWP7T/spectre/netlist.scs"
include "../../../logic/SAR_DRIVE/transistor/netlist.scs"
include "../../../logic/SAR_DELAY/transistor/netlist.scs"
include "../../../logic/SAR_DELAY4/transistor/netlist.scs"
subckt SAR_ASYNC (Sample Valid ClkC Done Ck9 Ck8 Ck7 Ck6 Ck5 Ck4 Ck3 Ck2 Ck1 Ck0 VDD VSS)
I_sample_inv (Sample ClearN VDD VSS) SAR_DRIVE scale=8
I_seq0 (VDD Valid ClearN Ck9 VDD VSS) DFCNQD1BWP7T
I_seq1 (Ck9 Valid ClearN Ck8 VDD VSS) DFCNQD1BWP7T
I_seq2 (Ck8 Valid ClearN Ck7 VDD VSS) DFCNQD1BWP7T
I_seq3 (Ck7 Valid ClearN Ck6 VDD VSS) DFCNQD1BWP7T
I_seq4 (Ck6 Valid ClearN Ck5 VDD VSS) DFCNQD1BWP7T
I_seq5 (Ck5 Valid ClearN Ck4 VDD VSS) DFCNQD1BWP7T
I_seq6 (Ck4 Valid ClearN Ck3 VDD VSS) DFCNQD1BWP7T
I_seq7 (Ck3 Valid ClearN Ck2 VDD VSS) DFCNQD1BWP7T
I_seq8 (Ck2 Valid ClearN Ck1 VDD VSS) DFCNQD1BWP7T
I_seq9 (Ck1 Valid ClearN Ck0 VDD VSS) DFCNQD1BWP7T
I_sample_guard (Sample SampleGuard VDD VSS) SAR_DELAY4
I_feedback_delay (Valid ValidDelay VDD VSS) SAR_DELAY4
I_run_nor (SampleGuard ValidDelay Ck0 CompareEnable VDD VSS) NR3D1BWP7T
I_clock_drive (CompareEnable ClkC VDD VSS) SAR_DRIVE scale=1
I_done_delay (Ck0 Done VDD VSS) SAR_DELAY
ends SAR_ASYNC
