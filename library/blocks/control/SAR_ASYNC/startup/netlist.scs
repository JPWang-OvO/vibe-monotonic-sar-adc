simulator lang=spectre
include "../../../logic/SAR_HANDSHAKE/transistor/netlist.scs"
// MOS D G S B; Spectre W = CDF wf = total width; CDF w = W/nf.
include "../../../logic/SAR_DFFR/transistor/netlist.scs"
include "../../../logic/SAR_NOR4/transistor/netlist.scs"
include "../../../logic/SAR_DRIVE/transistor/netlist.scs"
include "../../../logic/SAR_DONE_DELAY/transistor/netlist.scs"
include "../../../logic/SAR_SAMPLE_GUARD12/transistor/netlist.scs"
include "../../../logic/SAR_STARTUP/transistor/netlist.scs"
subckt SAR_ASYNC (Sample Valid ClkC Done Ck9 Ck8 Ck7 Ck6 Ck5 Ck4 Ck3 Ck2 Ck1 Ck0 VDD VSS)
I_startup (Sample SampleGuard Hold ClearN VDD VSS) SAR_STARTUP
I_seq0 (VDD Valid ClearN Ck9 VDD VSS) SAR_DFFR
I_seq1 (Ck9 Valid ClearN Ck8 VDD VSS) SAR_DFFR
I_seq2 (Ck8 Valid ClearN Ck7 VDD VSS) SAR_DFFR
I_seq3 (Ck7 Valid ClearN Ck6 VDD VSS) SAR_DFFR
I_seq4 (Ck6 Valid ClearN Ck5 VDD VSS) SAR_DFFR
I_seq5 (Ck5 Valid ClearN Ck4 VDD VSS) SAR_DFFR
I_seq6 (Ck4 Valid ClearN Ck3 VDD VSS) SAR_DFFR
I_seq7 (Ck3 Valid ClearN Ck2 VDD VSS) SAR_DFFR
I_seq8 (Ck2 Valid ClearN Ck1 VDD VSS) SAR_DFFR
I_seq9 (Ck1 Valid ClearN Ck0 VDD VSS) SAR_DFFR
I_sample_guard (Sample SampleGuard VDD VSS) SAR_SAMPLE_GUARD12
I_feedback_delay (Valid ValidDelay VDD VSS) SAR_HANDSHAKE
I_run_nor (Hold Valid ValidDelay Ck0 CompareEnable VDD VSS) SAR_NOR4
I_clock_drive (CompareEnable ClkC VDD VSS) SAR_DRIVE scale=4
I_done_delay (Ck0 Done VDD VSS) SAR_DONE_DELAY
ends SAR_ASYNC
