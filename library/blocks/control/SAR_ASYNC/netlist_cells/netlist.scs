simulator lang=spectre
include "../../../logic/SAR_HANDSHAKE/netlist/netlist.scs"
// MOS D G S B; Spectre W = CDF wf = total width; CDF w = W/nf.
include "../../../logic/SAR_FAST_SEQ/netlist/netlist.scs"
include "../../../logic/SAR_WAIT_GATE/netlist/netlist.scs"
include "../../../../support/standard_cells/INVD1BWP7T/netlist/netlist.scs"
include "../../../../support/standard_cells/INVD2BWP7T/netlist/netlist.scs"
include "../../../../support/standard_cells/INVD4BWP7T/netlist/netlist.scs"
include "../../../logic/SAR_DONE_DELAY/netlist/netlist.scs"
include "../../../logic/SAR_SAMPLE_GUARD2/netlist_quiet/netlist.scs"
include "../../../logic/SAR_STARTUP/netlist/netlist.scs"
subckt SAR_ASYNC (Sample Valid ClkC Done Ck\<9\> Ck\<8\> Ck\<7\> Ck\<6\> Ck\<5\> Ck\<4\> Ck\<3\> Ck\<2\> Ck\<1\> Ck\<0\> VDD VSS)
I_startup (Sample SampleGuard Hold ClearN VDD VSS) SAR_STARTUP
I_cp0 (Valid SeqB VDD VSS) INVD2BWP7T
I_cp1 (SeqB Seq VDD VSS) INVD4BWP7T
I_reset (ClearN Reset VDD VSS) INVD4BWP7T
I_seq0 (VDD Seq SeqB Reset Ck\<9\> VDD VSS) SAR_FAST_SEQ
I_seq1 (Ck\<9\> Seq SeqB Reset Ck\<8\> VDD VSS) SAR_FAST_SEQ
I_seq2 (Ck\<8\> Seq SeqB Reset Ck\<7\> VDD VSS) SAR_FAST_SEQ
I_seq3 (Ck\<7\> Seq SeqB Reset Ck\<6\> VDD VSS) SAR_FAST_SEQ
I_seq4 (Ck\<6\> Seq SeqB Reset Ck\<5\> VDD VSS) SAR_FAST_SEQ
I_seq5 (Ck\<5\> Seq SeqB Reset Ck\<4\> VDD VSS) SAR_FAST_SEQ
I_seq6 (Ck\<4\> Seq SeqB Reset Ck\<3\> VDD VSS) SAR_FAST_SEQ
I_seq7 (Ck\<3\> Seq SeqB Reset Ck\<2\> VDD VSS) SAR_FAST_SEQ
I_seq8 (Ck\<2\> Seq SeqB Reset Ck\<1\> VDD VSS) SAR_FAST_SEQ
I_seq9 (Ck\<1\> Seq SeqB Reset Ck\<0\> VDD VSS) SAR_FAST_SEQ
I_sample_guard (Sample SampleGuard VDD VSS) SAR_SAMPLE_GUARD2
I_feedback_delay (Valid ValidDelay VDD VSS) SAR_HANDSHAKE
I_early (Ck\<5\> Early VDD VSS) INVD1BWP7T
I_run_nor (Hold Valid Ck\<0\> ValidDelay Early CompareEnable VDD VSS) SAR_WAIT_GATE
I_clock_drive (CompareEnable ClkC VDD VSS) INVD4BWP7T
I_done_delay (Ck\<0\> Done VDD VSS) SAR_DONE_DELAY
ends SAR_ASYNC
