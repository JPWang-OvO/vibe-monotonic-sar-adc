`include "constants.vams"
`include "disciplines.vams"
module SAR_ASYNC_va(Sample,Valid,ClkC,Done,Ck9,Ck8,Ck7,Ck6,Ck5,Ck4,Ck3,Ck2,Ck1,Ck0,VDD,VSS);
input Sample,Valid,VDD,VSS;output ClkC,Done,Ck9,Ck8,Ck7,Ck6,Ck5,Ck4,Ck3,Ck2,Ck1,Ck0;
electrical Sample,Valid,ClkC,Done,Ck9,Ck8,Ck7,Ck6,Ck5,Ck4,Ck3,Ck2,Ck1,Ck0,VDD,VSS;
parameter real tsettle=300p;
integer clock_reset,done,bit_index,running;
integer ck[0:9];
integer i;real next_eval;
analog begin
 @(initial_step) begin clock_reset=1;done=0;bit_index=9;running=0;next_eval=1e9;for(i=0;i<10;i=i+1)ck[i]=0;end
 @(cross(V(Sample,VSS)-0.9,+1)) begin clock_reset=1;done=0;running=0;bit_index=9;for(i=0;i<10;i=i+1)ck[i]=0;end
 @(cross(V(Sample,VSS)-0.9,-1)) begin running=1;next_eval=$abstime+tsettle;end
 @(timer(next_eval)) begin if(running && !done)clock_reset=0;end
 @(cross(V(Valid,VSS)-0.9,+1)) begin
  if(running && !clock_reset && !done) begin
   ck[bit_index]=1;clock_reset=1;
   if(bit_index==0)begin done=1;running=0;end
   else begin bit_index=bit_index-1;next_eval=$abstime+tsettle;end
  end
 end
 V(ClkC,VSS)<+transition(clock_reset*1.8,20p,1p,1p);
 V(Done,VSS)<+transition(done*1.8,60p,1p,1p);
 V(Ck0,VSS)<+transition(ck[0]*1.8,0,1p,1p);
 V(Ck1,VSS)<+transition(ck[1]*1.8,0,1p,1p);
 V(Ck2,VSS)<+transition(ck[2]*1.8,0,1p,1p);
 V(Ck3,VSS)<+transition(ck[3]*1.8,0,1p,1p);
 V(Ck4,VSS)<+transition(ck[4]*1.8,0,1p,1p);
 V(Ck5,VSS)<+transition(ck[5]*1.8,0,1p,1p);
 V(Ck6,VSS)<+transition(ck[6]*1.8,0,1p,1p);
 V(Ck7,VSS)<+transition(ck[7]*1.8,0,1p,1p);
 V(Ck8,VSS)<+transition(ck[8]*1.8,0,1p,1p);
 V(Ck9,VSS)<+transition(ck[9]*1.8,0,1p,1p);
end
endmodule
