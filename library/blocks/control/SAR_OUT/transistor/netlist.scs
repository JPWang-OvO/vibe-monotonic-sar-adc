simulator lang=spectre
// MOS D G S B; Spectre W = CDF wf = total width; CDF w = W/nf.
include "../../../../support/standard_cells/DFQD1BWP7T/spectre/netlist.scs"
include "../../../logic/SAR_DRIVE/transistor/netlist.scs"
subckt SAR_OUT (D Done Q VDD VSS)
I_latch (D Done Stored VDD VSS) DFQD1BWP7T
I_buf0 (Stored StoredB VDD VSS) SAR_DRIVE scale=1
I_buf1 (StoredB Q VDD VSS) SAR_DRIVE scale=2
ends SAR_OUT
