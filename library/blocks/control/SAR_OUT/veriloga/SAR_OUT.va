`include "constants.vams"
`include "disciplines.vams"
module SAR_OUT_va(D,Done,Q,VDD,VSS);
input D,Done,VDD,VSS;output Q;electrical D,Done,Q,VDD,VSS;integer q;
analog begin
 @(initial_step)q=0;
 @(cross(V(Done,VSS)-0.9,+1))q=(V(D,VSS)>=0.9);
 V(Q,VSS)<+transition(q*1.8,0,1p,1p);
end
endmodule
