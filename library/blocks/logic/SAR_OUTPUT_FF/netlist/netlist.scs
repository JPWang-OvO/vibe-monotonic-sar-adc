simulator lang=spectre
// MOS D G S B; Spectre W = CDF wf = total width; CDF w = W/nf.
subckt SAR_OUTPUT_FF (D CP Q VDD VSS)
Mn_cp (CPB CP VSS VSS) nch w=1u l=0.18u nf=1 m=1
Mp_cp (CPB CP VDD VDD) pch w=2u l=0.18u nf=1 m=1
Mn_d (DB D VSS VSS) nch w=1u l=0.18u nf=1 m=1
Mp_d (DB D VDD VDD) pch w=2u l=0.18u nf=1 m=1
Mn_mi (M CPB DB VSS) nch w=0.5u l=0.18u nf=1 m=1
Mp_mi (M CP DB VDD) pch w=1u l=0.18u nf=1 m=1
Mn_md (MD M VSS VSS) nch w=0.5u l=0.18u nf=1 m=1
Mp_md (MD M VDD VDD) pch w=1u l=0.18u nf=1 m=1
Mn_mb (MB MD VSS VSS) nch w=1u l=0.18u nf=1 m=1
Mp_mb (MB MD VDD VDD) pch w=2u l=0.18u nf=1 m=1
Mn_mf (M CP MB VSS) nch w=0.5u l=0.18u nf=1 m=1
Mp_mf (M CPB MB VDD) pch w=1u l=0.18u nf=1 m=1
Mn_si (S CP MB VSS) nch w=1.5u l=0.18u nf=1 m=1
Mp_si (S CPB MB VDD) pch w=3u l=0.18u nf=1 m=1
Mn_q (Q S VSS VSS) nch w=2u l=0.18u nf=1 m=1
Mp_q (Q S VDD VDD) pch w=4u l=0.18u nf=1 m=1
Mn_sb (SB Q VSS VSS) nch w=0.5u l=0.18u nf=1 m=1
Mp_sb (SB Q VDD VDD) pch w=1u l=0.18u nf=1 m=1
Mn_sf (S CPB SB VSS) nch w=0.5u l=0.18u nf=1 m=1
Mp_sf (S CP SB VDD) pch w=1u l=0.18u nf=1 m=1
ends SAR_OUTPUT_FF
