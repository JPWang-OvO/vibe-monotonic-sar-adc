simulator lang=spectre
// MOS D G S B; Spectre W = CDF wf = total width; CDF w = W/nf.
subckt SAR_CAPTURE_LATCH (D Hold Q QB VDD VSS)
Mn_h (HoldB Hold VSS VSS) nch w=1u l=0.18u nf=1 m=1
Mp_h (HoldB Hold VDD VDD) pch w=2u l=0.18u nf=1 m=1
Mn_in (N HoldB D VSS) nch w=1u l=0.18u nf=1 m=1
Mp_in (N Hold D VDD) pch w=2u l=0.18u nf=1 m=1
Mn_fb (N Hold Q VSS) nch w=1u l=0.18u nf=1 m=1
Mp_fb (N HoldB Q VDD) pch w=2u l=0.18u nf=1 m=1
Mn_qb (QB N VSS VSS) nch w=1u l=0.18u nf=1 m=1
Mp_qb (QB N VDD VDD) pch w=2u l=0.18u nf=1 m=1
Mn_q (Q QB VSS VSS) nch w=1u l=0.18u nf=1 m=1
Mp_q (Q QB VDD VDD) pch w=2u l=0.18u nf=1 m=1
ends SAR_CAPTURE_LATCH
