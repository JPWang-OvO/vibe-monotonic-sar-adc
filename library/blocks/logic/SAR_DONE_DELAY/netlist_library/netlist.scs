simulator lang=spectre
include "../../../../support/standard_cells/INVD1BWP7T/netlist/netlist.scs"
include "../../../../support/standard_cells/INVD4BWP7T/netlist/netlist.scs"
subckt SAR_DONE_DELAY (A Z VDD VSS)
I_b0 (A N0 VDD VSS) INVD1BWP7T
I_b1 (N0 Z VDD VSS) INVD4BWP7T
ends SAR_DONE_DELAY
