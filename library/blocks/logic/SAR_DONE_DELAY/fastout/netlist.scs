simulator lang=spectre
include "../../../logic/SAR_DRIVE/transistor/netlist.scs"
subckt SAR_DONE_DELAY (A Z VDD VSS)
I_b0 (A N0 VDD VSS) SAR_DRIVE scale=4
I_b1 (N0 Z VDD VSS) SAR_DRIVE scale=16
ends SAR_DONE_DELAY
