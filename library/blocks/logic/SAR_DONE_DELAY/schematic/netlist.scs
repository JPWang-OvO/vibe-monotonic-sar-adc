simulator lang=spectre
subckt SAR_DONE_DELAY (A Z VDD VSS)
I_b1 (N0 Z VDD VSS) SAR_DRIVE _par0=16
I_b0 (A N0 VDD VSS) SAR_DRIVE _par0=4
ends SAR_DONE_DELAY
