simulator lang=spectre
// MOS D G S B; Spectre W = CDF wf = total width; CDF w = W/nf.
subckt SAR_NOR4 (A B C D Z VDD VSS)
Mn0 (Z A VSS VSS) nch w=4u l=0.18u nf=1 m=1
Mp0 (P0 A VDD VDD) pch w=24u l=0.18u nf=3 m=1
Mn1 (Z B VSS VSS) nch w=4u l=0.18u nf=1 m=1
Mp1 (P1 B P0 VDD) pch w=24u l=0.18u nf=3 m=1
Mn2 (Z C VSS VSS) nch w=4u l=0.18u nf=1 m=1
Mp2 (P2 C P1 VDD) pch w=24u l=0.18u nf=3 m=1
Mn3 (Z D VSS VSS) nch w=4u l=0.18u nf=1 m=1
Mp3 (Z D P2 VDD) pch w=24u l=0.18u nf=3 m=1
ends SAR_NOR4
