simulator lang=spectre
// MOS D G S B; Spectre W = CDF wf = total width; CDF w = W/nf.
subckt SAR_FAST_SEQ (D CP CPB Reset Q VDD VSS)
Mn_d (DB D VSS VSS) nch w=1u l=0.18u nf=1 m=1
Mp_d (DB D VDD VDD) pch w=2u l=0.18u nf=1 m=1
Mn_mi (M CPB DB VSS) nch w=2u l=0.18u nf=1 m=1
Mp_mi (M CP DB VDD) pch w=4u l=0.18u nf=1 m=1
Mn_ma (MD M VSS VSS) nch w=1u l=0.18u nf=1 m=1
Mn_mb (MD Reset VSS VSS) nch w=1u l=0.18u nf=1 m=1
Mp_ma (Pm M VDD VDD) pch w=4u l=0.18u nf=1 m=1
Mp_mb (MD Reset Pm VDD) pch w=4u l=0.18u nf=1 m=1
Mn_master_buf (MB MD VSS VSS) nch w=2u l=0.18u nf=1 m=1
Mp_master_buf (MB MD VDD VDD) pch w=4u l=0.18u nf=1 m=1
Mn_mf (M CP MB VSS) nch w=2u l=0.18u nf=1 m=1
Mp_mf (M CPB MB VDD) pch w=4u l=0.18u nf=1 m=1
Mn_si (S CP MB VSS) nch w=4u l=0.18u nf=1 m=1
Mp_si (S CPB MB VDD) pch w=8u l=0.18u nf=1 m=1
Mn_qa (Q S VSS VSS) nch w=4u l=0.18u nf=1 m=1
Mn_qb (Q Reset VSS VSS) nch w=4u l=0.18u nf=1 m=1
Mp_qa (Pq S VDD VDD) pch w=12u l=0.18u nf=2 m=1
Mp_qb (Q Reset Pq VDD) pch w=12u l=0.18u nf=2 m=1
Mn_sb (SB Q VSS VSS) nch w=1u l=0.18u nf=1 m=1
Mp_sb (SB Q VDD VDD) pch w=2u l=0.18u nf=1 m=1
Mn_sf (S CPB SB VSS) nch w=2u l=0.18u nf=1 m=1
Mp_sf (S CP SB VDD) pch w=4u l=0.18u nf=1 m=1
ends SAR_FAST_SEQ
