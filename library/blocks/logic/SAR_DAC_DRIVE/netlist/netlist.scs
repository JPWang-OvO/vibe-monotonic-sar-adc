simulator lang=spectre
subckt SAR_DAC_DRIVE (A Z VDD VSS)
parameters scale=1
Mn (Z A VSS VSS) nch w=1u l=180n nf=1 m=2*scale
Mp (Z A VDD VDD) pch w=3u l=180n nf=1 m=2*scale
ends SAR_DAC_DRIVE
