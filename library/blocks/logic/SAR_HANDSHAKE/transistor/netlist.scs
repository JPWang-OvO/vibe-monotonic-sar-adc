simulator lang=spectre
// MOS D G S B; Spectre W = CDF wf = total width; CDF w = W/nf.
include "../../../logic/SAR_DRIVE/transistor/netlist.scs"
subckt SAR_HANDSHAKE (A Z VDD VSS)
I_b0 (A N0 VDD VSS) SAR_DRIVE scale=1
I_b1 (N0 Z VDD VSS) SAR_DRIVE scale=4
ends SAR_HANDSHAKE
