simulator lang=spectre
include "../../../../support/standard_cells/INVD1BWP7T/netlist/netlist.scs"
include "../../../../support/standard_cells/ND2D1BWP7T/netlist/netlist.scs"
include "../../../../support/standard_cells/NR3D1BWP7T/netlist/netlist.scs"
subckt SAR_WAIT_GATE (Hold Valid Done Delayed Early Z VDD VSS)
I_a (Hold Valid Done AN VDD VSS) NR3D1BWP7T
I_b (Delayed Early BN VDD VSS) ND2D1BWP7T
I_c (AN BN ZN VDD VSS) ND2D1BWP7T
I_d (ZN Z VDD VSS) INVD1BWP7T
ends SAR_WAIT_GATE
