simulator lang=spectre
subckt SAR_WAIT_GATE (Hold Valid Done Delayed Early Z VDD VSS)
Mn_early (Ndelay Early VSS VSS) nch l=0.18u w=22u m=1 nf=4 sd=540.0n ad=5.94e-12 as=8.25e-12 pd=24.160u ps=36.0u nrd=0.0122727 nrs=0.0122727 sa=480.0n sb=480.0n sca=0 scb=0 scc=0
Mn_delay (Z Delayed Ndelay VSS) nch l=0.18u w=22u m=1 nf=4 sd=540.0n ad=5.94e-12 as=8.25e-12 pd=24.160u ps=36.0u nrd=0.0122727 nrs=0.0122727 sa=480.0n sb=480.0n sca=0 scb=0 scc=0
Mn_Done (Z Done VSS VSS) nch l=0.18u w=4u m=1 nf=1 sd=540.0n ad=1.92e-12 as=1.92e-12 pd=8.96u ps=8.96u nrd=0.0675 nrs=0.0675 sa=480.0n sb=480.0n sca=0 scb=0 scc=0
Mn_Valid (Z Valid VSS VSS) nch l=0.18u w=4u m=1 nf=1 sd=540.0n ad=1.92e-12 as=1.92e-12 pd=8.96u ps=8.96u nrd=0.0675 nrs=0.0675 sa=480.0n sb=480.0n sca=0 scb=0 scc=0
Mn_Hold (Z Hold VSS VSS) nch l=0.18u w=4u m=1 nf=1 sd=540.0n ad=1.92e-12 as=1.92e-12 pd=8.96u ps=8.96u nrd=0.0675 nrs=0.0675 sa=480.0n sb=480.0n sca=0 scb=0 scc=0
Mp_valid (Z Valid P2 VDD) pch l=0.18u w=24u m=1 nf=3 sd=540.0n ad=8.16e-12 as=8.16e-12 pd=34.040u ps=34.040u nrd=0.01125 nrs=0.01125 sa=480.0n sb=480.0n sca=0 scb=0 scc=0
Mp_early (P2 Early P1 VDD) pch l=0.18u w=24u m=1 nf=3 sd=540.0n ad=8.16e-12 as=8.16e-12 pd=34.040u ps=34.040u nrd=0.01125 nrs=0.01125 sa=480.0n sb=480.0n sca=0 scb=0 scc=0
Mp_delay (P2 Delayed P1 VDD) pch l=0.18u w=24u m=1 nf=3 sd=540.0n ad=8.16e-12 as=8.16e-12 pd=34.040u ps=34.040u nrd=0.01125 nrs=0.01125 sa=480.0n sb=480.0n sca=0 scb=0 scc=0
Mp_done (P1 Done P0 VDD) pch l=0.18u w=24u m=1 nf=3 sd=540.0n ad=8.16e-12 as=8.16e-12 pd=34.040u ps=34.040u nrd=0.01125 nrs=0.01125 sa=480.0n sb=480.0n sca=0 scb=0 scc=0
Mp_hold (P0 Hold VDD VDD) pch l=0.18u w=24u m=1 nf=3 sd=540.0n ad=8.16e-12 as=8.16e-12 pd=34.040u ps=34.040u nrd=0.01125 nrs=0.01125 sa=480.0n sb=480.0n sca=0 scb=0 scc=0
C_stack (P2 VDD) capacitor c=240f
ends SAR_WAIT_GATE
