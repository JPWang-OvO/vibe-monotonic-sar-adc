simulator lang=spectre
// MOS D G S B; Spectre W = CDF wf = total width; CDF w = W/nf.
subckt SAR_WAIT_GATE (Hold Valid Done Delayed Early Z VDD VSS)
Mn_Hold (Z Hold VSS VSS) nch w=4u l=0.18u nf=1 m=1
Mn_Valid (Z Valid VSS VSS) nch w=4u l=0.18u nf=1 m=1
Mn_Done (Z Done VSS VSS) nch w=4u l=0.18u nf=1 m=1
Mn_delay (Z Delayed Ndelay VSS) nch w=32u l=0.18u nf=4 m=1
Mn_early (Ndelay Early VSS VSS) nch w=32u l=0.18u nf=4 m=1
Mp_hold (P0 Hold VDD VDD) pch w=24u l=0.18u nf=3 m=1
Mp_done (P1 Done P0 VDD) pch w=24u l=0.18u nf=3 m=1
Mp_delay (P2 Delayed P1 VDD) pch w=24u l=0.18u nf=3 m=1
Mp_early (P2 Early P1 VDD) pch w=24u l=0.18u nf=3 m=1
Mp_valid (Z Valid P2 VDD) pch w=24u l=0.18u nf=3 m=1
C_stack (P2 VDD) capacitor c=240f
ends SAR_WAIT_GATE
