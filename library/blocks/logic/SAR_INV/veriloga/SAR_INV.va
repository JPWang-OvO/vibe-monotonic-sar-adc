`include "constants.vams"
`include "disciplines.vams"
module SAR_INV_va(A,Z,VDD,VSS);
input A,VDD,VSS;output Z;electrical A,Z,VDD,VSS;
integer q;
analog begin
 @(initial_step) q=1;
 @(cross(V(A,VSS)-0.9,0)) q=(V(A,VSS)<0.9);
 V(Z,VSS)<+transition(q*1.8,0,1p,1p);
end
endmodule
