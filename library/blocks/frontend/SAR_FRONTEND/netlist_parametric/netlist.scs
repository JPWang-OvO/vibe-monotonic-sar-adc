simulator lang=spectre
// MOS D G S B; Spectre W = CDF wf = total width; CDF w = W/nf.
include "../../../sampling/SAR_SAMPLE/netlist/netlist.scs"
include "../../../dac/SAR_CDAC/netlist/netlist.scs"
subckt SAR_FRONTEND (Vinp Vinn Sample SampleB Vp Vn Bp\<9\> Bp\<8\> Bp\<7\> Bp\<6\> Bp\<5\> Bp\<4\> Bp\<3\> Bp\<2\> Bp\<1\> Bn\<9\> Bn\<8\> Bn\<7\> Bn\<6\> Bn\<5\> Bn\<4\> Bn\<3\> Bn\<2\> Bn\<1\> VREFP VREFN VDD VSS)
parameters ccross=38f unit_cap=20f
I_sp (Vinp Vp Sample SampleB Gp VDD VSS) SAR_SAMPLE
I_sn (Vinn Vn Sample SampleB Gn VDD VSS) SAR_SAMPLE
C_cross_p (Gp Vn) capacitor c=ccross
C_cross_n (Gn Vp) capacitor c=ccross
I_cdac (Vp Vn Bp\<9\> Bp\<8\> Bp\<7\> Bp\<6\> Bp\<5\> Bp\<4\> Bp\<3\> Bp\<2\> Bp\<1\> Bn\<9\> Bn\<8\> Bn\<7\> Bn\<6\> Bn\<5\> Bn\<4\> Bn\<3\> Bn\<2\> Bn\<1\> VREFP VREFN) SAR_CDAC unit_cap=unit_cap
ends SAR_FRONTEND
