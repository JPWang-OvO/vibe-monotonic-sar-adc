simulator lang=spectre
// MOS D G S B; Spectre W = CDF wf = total width; CDF w = W/nf.
include "../../../sampling/SAR_SAMPLE/transistor/netlist.scs"
include "../../../dac/SAR_CDAC/spectre/netlist.scs"
subckt SAR_FRONTEND (Vinp Vinn Sample SampleB Vp Vn Bp9 Bp8 Bp7 Bp6 Bp5 Bp4 Bp3 Bp2 Bp1 Bn9 Bn8 Bn7 Bn6 Bn5 Bn4 Bn3 Bn2 Bn1 VREFP VREFN VDD VSS)
I_sp (Vinp Vp Sample SampleB VDD VSS) SAR_SAMPLE
I_sn (Vinn Vn Sample SampleB VDD VSS) SAR_SAMPLE
I_cdac (Vp Vn Bp9 Bp8 Bp7 Bp6 Bp5 Bp4 Bp3 Bp2 Bp1 Bn9 Bn8 Bn7 Bn6 Bn5 Bn4 Bn3 Bn2 Bn1 VREFP VREFN) SAR_CDAC
ends SAR_FRONTEND
