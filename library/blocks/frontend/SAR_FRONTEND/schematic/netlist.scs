simulator lang=spectre
subckt SAR_FRONTEND (Vinp Vinn Sample SampleB Vp Vn Bp9 Bp8 Bp7 Bp6 Bp5 Bp4 Bp3 Bp2 Bp1 Bn9 Bn8 Bn7 Bn6 Bn5 Bn4 Bn3 Bn2 Bn1 VREFP VREFN VDD VSS)
parameters unit_cap=24f ccross=28f
I_cdac (Vp Vn Bp9 Bp8 Bp7 Bp6 Bp5 Bp4 Bp3 Bp2 Bp1 Bn9 Bn8 Bn7 Bn6 Bn5 Bn4 Bn3 Bn2 Bn1 VREFP VREFN) SAR_CDAC unit_cap=unit_cap
I_sample\<1\> (Vinp Vp Sample SampleB Gp VDD VSS) SAR_SAMPLE
I_sample\<0\> (Vinn Vn Sample SampleB Gn VDD VSS) SAR_SAMPLE
C_cross\<1\> (Gp Vn) capacitor c=ccross
C_cross\<0\> (Gn Vp) capacitor c=ccross
ends SAR_FRONTEND
