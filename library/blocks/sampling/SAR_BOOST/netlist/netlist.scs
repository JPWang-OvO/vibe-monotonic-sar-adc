simulator lang=spectre
subckt SAR_BOOST (Vin Gate Sample SampleB VDD VSS)
C_boot (Ct Cb) capacitor c=500f
Mp_precharge (Ct Gate VDD Ct) pch w=4u l=0.18u nf=1 m=1
Mp_transfer (Gate Q Ct Ct) pch w=4u l=0.18u nf=1 m=1
Mp_start (Q Sample VDD Ct) pch w=2u l=0.18u nf=1 m=1
Mn_start (Q Sample Cb VSS) nch w=1u l=0.18u nf=1 m=1
Mn_trackq (Q Gate Cb VSS) nch w=1u l=0.18u nf=1 m=1
Mn_bottom (Cb Gate Vin VSS) nch w=8u l=0.18u nf=2 m=1
Mn_reset_bottom (Cb SampleB VSS VSS) nch w=2u l=0.18u nf=1 m=1
Mn_reset_cascode (Gate VDD ResetMid VSS) nch w=2u l=0.18u nf=1 m=1
Mn_reset_gate (ResetMid SampleB VSS VSS) nch w=2u l=0.18u nf=1 m=1
ends SAR_BOOST
