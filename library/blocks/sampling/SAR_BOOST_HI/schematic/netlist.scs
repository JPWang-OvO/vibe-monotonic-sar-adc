simulator lang=spectre
subckt SAR_BOOST_HI (Vin Gate Sample SampleB VDD VSS)
C_boot (Ct Cb) capacitor c=80p
Mp_bottom (Cb SampleB Vin Ct) pch_5 l=0.5u w=2048u m=1 nf=256 sd=540.0n ad=5.5296e-10 as=5.5632e-10 pd=2.18624000m ps=2.20308000m nrd=0.000131836 nrs=0.000131836 sa=480.0n sb=480.0n sca=0 scb=0 scc=0
Mp_start (Q Sample VDD Ct) pch_5 l=0.5u w=256u m=1 nf=32 sd=540.0n ad=6.912e-11 as=7.248e-11 pd=273.28000000u ps=290.12000000u nrd=0.00105469 nrs=0.00105469 sa=480.0n sb=480.0n sca=0 scb=0 scc=0
Mp_transfer (Gate Q Ct Ct) pch_5 l=0.5u w=1024u m=1 nf=128 sd=540.0n ad=2.7648e-10 as=2.7984e-10 pd=1.09312000m ps=1.10996000m nrd=0.000263672 nrs=0.000263672 sa=480.0n sb=480.0n sca=0 scb=0 scc=0
Mp_precharge (Ct Gate VDD Ct) pch_5 l=0.5u w=1024u m=1 nf=128 sd=540.0n ad=2.7648e-10 as=2.7984e-10 pd=1.09312000m ps=1.10996000m nrd=0.000263672 nrs=0.000263672 sa=480.0n sb=480.0n sca=0 scb=0 scc=0
Mn_reset_gate (Gate SampleB VSS VSS) nch_5 l=0.6u w=1024u m=1 nf=128 sd=540.0n ad=2.7648e-10 as=2.7984e-10 pd=1.09312000m ps=1.10996000m nrd=0.000263672 nrs=0.000263672 sa=480.0n sb=480.0n sca=0 scb=0 scc=0
Mn_reset_bottom (Cb SampleB VSS VSS) nch_5 l=0.6u w=2048u m=1 nf=256 sd=540.0n ad=5.5296e-10 as=5.5632e-10 pd=2.18624000m ps=2.20308000m nrd=0.000131836 nrs=0.000131836 sa=480.0n sb=480.0n sca=0 scb=0 scc=0
Mn_trackq (Q Gate Cb VSS) nch_5 l=0.6u w=256u m=1 nf=32 sd=540.0n ad=6.912e-11 as=7.248e-11 pd=273.28000000u ps=290.12000000u nrd=0.00105469 nrs=0.00105469 sa=480.0n sb=480.0n sca=0 scb=0 scc=0
Mn_start (Q Sample Cb VSS) nch_5 l=0.6u w=256u m=1 nf=32 sd=540.0n ad=6.912e-11 as=7.248e-11 pd=273.28000000u ps=290.12000000u nrd=0.00105469 nrs=0.00105469 sa=480.0n sb=480.0n sca=0 scb=0 scc=0
ends SAR_BOOST_HI
