`include "constants.vams"
`include "disciplines.vams"
module SAR_SAMPLE_va(Vin,Top,Sample,SampleB,Gate,VDD,VSS);
inout Vin,Top; input Sample,SampleB,VDD,VSS; output Gate;
electrical Vin,Top,Sample,SampleB,Gate,VDD,VSS;
integer on;
analog begin
 @(initial_step) on=0;
 @(cross(V(Sample,VSS)-0.9,+1)) on=1;
 @(cross(V(Sample,VSS)-0.9,-1)) on=0;
 V(Gate,VSS)<+transition(on,0,20p,20p)*(V(Vin,VSS)+V(VDD,VSS));
 if(on) V(Vin,Top)<+0;
 else I(Vin,Top)<+0;
end
endmodule
