ahdl_include "SAR_SAMPLE.va"
subckt SAR_SAMPLE (Vin Top Sample SampleB VDD VSS)
I_model (Vin Top Sample SampleB VDD VSS) SAR_SAMPLE_va
ends SAR_SAMPLE
