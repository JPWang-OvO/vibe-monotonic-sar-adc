simulator lang=spectre
// MOS D G S B; Spectre W = CDF wf = total width; CDF w = W/nf.
subckt SAR_SAMPLE (Vin Top Sample SampleB VDD VSS)
C_boot (Ct Cb) capacitor c=20p
Mp_precharge (Ct Gate VDD Ct) pch_5 w=256u l=0.5u nf=32 m=1
Mp_transfer (Gate Q Ct Ct) pch_5 w=256u l=0.5u nf=32 m=1
Mp_start (Q Sample VDD VDD) pch_5 w=64u l=0.5u nf=8 m=1
Mn_start (Q Sample Cb VSS) nch_5 w=64u l=0.6u nf=8 m=1
Mn_trackq (Q Gate Cb VSS) nch_5 w=64u l=0.6u nf=8 m=1
Mn_bottom (Cb Gate Vin VSS) nch_5 w=512u l=0.6u nf=64 m=1
Mn_reset_bottom (Cb SampleB VSS VSS) nch_5 w=512u l=0.6u nf=64 m=1
Mn_reset_gate_upper (Gate VDD ResetMid VSS) nch_5 w=32u l=0.6u nf=4 m=1
Mn_reset_gate_lower (ResetMid SampleB VSS VSS) nch_5 w=32u l=0.6u nf=4 m=1
Mn_sample (Top Gate Vin VSS) nch_5 w=256u l=0.6u nf=32 m=1
ends SAR_SAMPLE
