simulator lang=spectre
subckt SAR_BIAS (Bias VDD VSS)
Mp_diode (Bias Bias VDD VDD) pch w=0.25u l=0.36u nf=1 m=1
Mn_sink (Bias VDD VSS VSS) nch w=0.3u l=8u nf=1 m=1
C_bias (Bias VSS) capacitor c=100f
ends SAR_BIAS
