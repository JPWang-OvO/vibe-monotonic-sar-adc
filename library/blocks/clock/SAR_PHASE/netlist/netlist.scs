simulator lang=spectre
include "../../../../support/standard_cells/DFCNQD1BWP7T/netlist/netlist.scs"
include "../../../../support/standard_cells/DFSNQD1BWP7T/netlist/netlist.scs"
include "../../../../support/standard_cells/INVD1BWP7T/netlist/netlist.scs"
include "../../../../support/standard_cells/INVD2BWP7T/netlist/netlist.scs"
include "../../../../support/standard_cells/INVD8BWP7T/netlist/netlist.scs"
include "../../../../support/standard_cells/LNQD1BWP7T/netlist/netlist.scs"
include "../../../../support/standard_cells/ND2D1BWP7T/netlist/netlist.scs"
subckt SAR_PHASE (Clks Sample VDD VSS)
Mp_charge (PorRamp VSS VDD VDD) pch w=0.36u l=5u nf=1 m=1
C_por (PorRamp VSS) capacitor c=200f
I_por0 (PorRamp Por VDD VSS) INVD1BWP7T
I_por1 (Por PorN VDD VSS) INVD1BWP7T
I_enable__I_latch (PorN Clks ClockEnable VDD VSS) LNQD1BWP7T
I_enable__I_qb (ClockEnable ClockEnableB VDD VSS) INVD1BWP7T
I_gate (Clks ClockEnable ClockGatedB VDD VSS) ND2D1BWP7T
I_gatebuf (ClockGatedB ClockGated VDD VSS) INVD2BWP7T
I_clk0 (ClockGated ClksB VDD VSS) INVD2BWP7T
I_clock (ClksB Clock VDD VSS) INVD2BWP7T
I_ring0 (R4 Clock PorN R0 VDD VSS) DFCNQD1BWP7T
I_ring1 (R0 Clock PorN R1 VDD VSS) DFCNQD1BWP7T
I_ring2 (R1 Clock PorN R2 VDD VSS) DFCNQD1BWP7T
I_ring3 (R2 Clock PorN R3 VDD VSS) DFCNQD1BWP7T
I_ring4 (R3 Clock PorN R4 VDD VSS) DFSNQD1BWP7T
I_buffer0 (R0 SampleN0 VDD VSS) INVD2BWP7T
I_buffer1 (SampleN0 Sample VDD VSS) INVD8BWP7T
ends SAR_PHASE
