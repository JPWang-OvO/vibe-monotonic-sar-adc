`include "constants.vams"
`include "disciplines.vams"
module SAR_PHASE_va(Clks,Sample,VDD,VSS);
input Clks,VDD,VSS; output Sample; electrical Clks,Sample,VDD,VSS;
integer count,s;
analog begin
 @(initial_step) begin count=4;s=0;end
 @(cross(V(Clks,VSS)-0.9,+1)) begin count=(count+1)%5;s=(count==0);end
 V(Sample,VSS)<+transition(s*1.8,0,1p,1p);
end
endmodule
