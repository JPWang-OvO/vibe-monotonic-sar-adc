simulator lang=spectre
// MOS D G S B; Spectre W = CDF wf = total width; CDF w = W/nf.
include "../../../../support/standard_cells/INVD1BWP7T/netlist/netlist.scs"
include "../../../logic/SAR_DFFR/netlist/netlist.scs"
include "../../../logic/SAR_DFFS/netlist/netlist.scs"
include "../../../logic/SAR_DRIVE/netlist/netlist.scs"
include "../../../logic/SAR_CAPTURE_LATCH/netlist_drive/netlist.scs"
include "../../../logic/SAR_SELECT/netlist/netlist.scs"
subckt SAR_PHASE (Clks Sample VDD VSS)
Mp_charge (PorRamp VSS VDD VDD) pch w=0.36u l=5u nf=1 m=1
C_por (PorRamp VSS) capacitor c=200f
I_por0 (PorRamp Por VDD VSS) INVD1BWP7T
I_por1 (Por PorN VDD VSS) INVD1BWP7T
I_enable (PorN Clks ClockEnable ClockEnableB VDD VSS) SAR_CAPTURE_LATCH
I_gate (Clks ClockEnable ClockGatedB VDD VSS) SAR_SELECT factor=16
I_gatebuf (ClockGatedB ClockGated VDD VSS) SAR_DRIVE scale=4
I_clk0 (ClockGated ClksB VDD VSS) SAR_DRIVE scale=16
Mn_clock_slew (Clock ClksB VSS VSS) nch w=8u l=0.18u nf=1 m=1
Mp_clock_slew (Clock ClksB VDD VDD) pch w=16u l=0.18u nf=1 m=1
C_clock_slew (Clock VSS) capacitor c=320f
I_ring0 (R4 Clock PorN R0 VDD VSS) SAR_DFFR
I_ring1 (R0 Clock PorN R1 VDD VSS) SAR_DFFR
I_ring2 (R1 Clock PorN R2 VDD VSS) SAR_DFFR
I_ring3 (R2 Clock PorN R3 VDD VSS) SAR_DFFR
I_ring4 (R3 Clock PorN R4 VDD VSS) SAR_DFFS
I_buffer0 (R0 SampleN0 VDD VSS) SAR_DRIVE scale=1
I_buffer1 (SampleN0 SampleN1 VDD VSS) SAR_DRIVE scale=4
I_buffer2 (SampleN1 SampleN2 VDD VSS) SAR_DRIVE scale=16
I_buffer3 (SampleN2 Sample VDD VSS) SAR_DRIVE scale=64
ends SAR_PHASE
