simulator lang=spectre
// MOS D G S B; Spectre W = CDF wf = total width; CDF w = W/nf.
include "../../../../support/standard_cells/INVD1BWP7T/spectre/netlist.scs"
include "../../../logic/SAR_DFFR/transistor/netlist.scs"
include "../../../logic/SAR_DFFS/transistor/netlist.scs"
include "../../../logic/SAR_DRIVE/transistor/netlist.scs"
include "../../../logic/SAR_CAPTURE_LATCH/drive/netlist.scs"
include "../../../logic/SAR_SELECT/transistor/netlist.scs"
subckt SAR_PHASE (Clks Sample VDD VSS)
Mp_charge (PorRamp VSS VDD VDD) pch w=0.36u l=5u nf=1 m=1
C_por (PorRamp VSS) capacitor c=200f
I_por0 (PorRamp Por VDD VSS) INVD1BWP7T
I_por1 (Por PorN VDD VSS) INVD1BWP7T
I_enable (PorN Clks ClockEnable ClockEnableB VDD VSS) SAR_CAPTURE_LATCH
I_gate (Clks ClockEnable ClockGatedB VDD VSS) SAR_SELECT factor=16
I_gatebuf (ClockGatedB ClockGated VDD VSS) SAR_DRIVE scale=4
I_clk0 (ClockGated ClksB VDD VSS) SAR_DRIVE scale=16
Mn_clock_slew (Clock ClksB VSS VSS) nch w=8u l=0.18u nf=1 m=1
Mp_clock_slew (Clock ClksB VDD VDD) pch w=16u l=0.18u nf=1 m=1
C_clock_slew (Clock VSS) capacitor c=320f
I_ring0 (R4 Clock PorN R0 VDD VSS) SAR_DFFR
I_ring1 (R0 Clock PorN R1 VDD VSS) SAR_DFFR
I_ring2 (R1 Clock PorN R2 VDD VSS) SAR_DFFR
I_ring3 (R2 Clock PorN R3 VDD VSS) SAR_DFFR
I_ring4 (R3 Clock PorN R4 VDD VSS) SAR_DFFS
I_buffer0 (R0 SampleN0 VDD VSS) SAR_DRIVE scale=1
I_buffer1 (SampleN0 SampleN1 VDD VSS) SAR_DRIVE scale=8
I_buffer2 (SampleN1 SampleN2 VDD VSS) SAR_DRIVE scale=64
I_buffer3 (SampleN2 SampleN3 VDD VSS) SAR_DRIVE scale=512
I_pre0 (SampleN3 SampleN4 VDD VSS) SAR_DRIVE scale=512
I_pre1 (SampleN3 SampleN4 VDD VSS) SAR_DRIVE scale=512
I_pre2 (SampleN3 SampleN4 VDD VSS) SAR_DRIVE scale=512
I_pre3 (SampleN3 SampleN4 VDD VSS) SAR_DRIVE scale=512
I_pre4 (SampleN3 SampleN4 VDD VSS) SAR_DRIVE scale=512
I_pre5 (SampleN3 SampleN4 VDD VSS) SAR_DRIVE scale=512
I_pre6 (SampleN3 SampleN4 VDD VSS) SAR_DRIVE scale=512
I_pre7 (SampleN3 SampleN4 VDD VSS) SAR_DRIVE scale=512
I_final0 (SampleN4 Sample VDD VSS) SAR_DRIVE scale=512
I_final1 (SampleN4 Sample VDD VSS) SAR_DRIVE scale=512
I_final2 (SampleN4 Sample VDD VSS) SAR_DRIVE scale=512
I_final3 (SampleN4 Sample VDD VSS) SAR_DRIVE scale=512
I_final4 (SampleN4 Sample VDD VSS) SAR_DRIVE scale=512
I_final5 (SampleN4 Sample VDD VSS) SAR_DRIVE scale=512
I_final6 (SampleN4 Sample VDD VSS) SAR_DRIVE scale=512
I_final7 (SampleN4 Sample VDD VSS) SAR_DRIVE scale=512
I_final8 (SampleN4 Sample VDD VSS) SAR_DRIVE scale=512
I_final9 (SampleN4 Sample VDD VSS) SAR_DRIVE scale=512
I_final10 (SampleN4 Sample VDD VSS) SAR_DRIVE scale=512
I_final11 (SampleN4 Sample VDD VSS) SAR_DRIVE scale=512
I_final12 (SampleN4 Sample VDD VSS) SAR_DRIVE scale=512
I_final13 (SampleN4 Sample VDD VSS) SAR_DRIVE scale=512
I_final14 (SampleN4 Sample VDD VSS) SAR_DRIVE scale=512
I_final15 (SampleN4 Sample VDD VSS) SAR_DRIVE scale=512
I_final16 (SampleN4 Sample VDD VSS) SAR_DRIVE scale=512
I_final17 (SampleN4 Sample VDD VSS) SAR_DRIVE scale=512
I_final18 (SampleN4 Sample VDD VSS) SAR_DRIVE scale=512
I_final19 (SampleN4 Sample VDD VSS) SAR_DRIVE scale=512
I_final20 (SampleN4 Sample VDD VSS) SAR_DRIVE scale=512
I_final21 (SampleN4 Sample VDD VSS) SAR_DRIVE scale=512
I_final22 (SampleN4 Sample VDD VSS) SAR_DRIVE scale=512
I_final23 (SampleN4 Sample VDD VSS) SAR_DRIVE scale=512
I_final24 (SampleN4 Sample VDD VSS) SAR_DRIVE scale=512
I_final25 (SampleN4 Sample VDD VSS) SAR_DRIVE scale=512
I_final26 (SampleN4 Sample VDD VSS) SAR_DRIVE scale=512
I_final27 (SampleN4 Sample VDD VSS) SAR_DRIVE scale=512
I_final28 (SampleN4 Sample VDD VSS) SAR_DRIVE scale=512
I_final29 (SampleN4 Sample VDD VSS) SAR_DRIVE scale=512
I_final30 (SampleN4 Sample VDD VSS) SAR_DRIVE scale=512
I_final31 (SampleN4 Sample VDD VSS) SAR_DRIVE scale=512
I_final32 (SampleN4 Sample VDD VSS) SAR_DRIVE scale=512
I_final33 (SampleN4 Sample VDD VSS) SAR_DRIVE scale=512
I_final34 (SampleN4 Sample VDD VSS) SAR_DRIVE scale=512
I_final35 (SampleN4 Sample VDD VSS) SAR_DRIVE scale=512
I_final36 (SampleN4 Sample VDD VSS) SAR_DRIVE scale=512
I_final37 (SampleN4 Sample VDD VSS) SAR_DRIVE scale=512
I_final38 (SampleN4 Sample VDD VSS) SAR_DRIVE scale=512
I_final39 (SampleN4 Sample VDD VSS) SAR_DRIVE scale=512
I_final40 (SampleN4 Sample VDD VSS) SAR_DRIVE scale=512
I_final41 (SampleN4 Sample VDD VSS) SAR_DRIVE scale=512
I_final42 (SampleN4 Sample VDD VSS) SAR_DRIVE scale=512
I_final43 (SampleN4 Sample VDD VSS) SAR_DRIVE scale=512
I_final44 (SampleN4 Sample VDD VSS) SAR_DRIVE scale=512
I_final45 (SampleN4 Sample VDD VSS) SAR_DRIVE scale=512
I_final46 (SampleN4 Sample VDD VSS) SAR_DRIVE scale=512
I_final47 (SampleN4 Sample VDD VSS) SAR_DRIVE scale=512
I_final48 (SampleN4 Sample VDD VSS) SAR_DRIVE scale=512
I_final49 (SampleN4 Sample VDD VSS) SAR_DRIVE scale=512
I_final50 (SampleN4 Sample VDD VSS) SAR_DRIVE scale=512
I_final51 (SampleN4 Sample VDD VSS) SAR_DRIVE scale=512
I_final52 (SampleN4 Sample VDD VSS) SAR_DRIVE scale=512
I_final53 (SampleN4 Sample VDD VSS) SAR_DRIVE scale=512
I_final54 (SampleN4 Sample VDD VSS) SAR_DRIVE scale=512
I_final55 (SampleN4 Sample VDD VSS) SAR_DRIVE scale=512
I_final56 (SampleN4 Sample VDD VSS) SAR_DRIVE scale=512
I_final57 (SampleN4 Sample VDD VSS) SAR_DRIVE scale=512
I_final58 (SampleN4 Sample VDD VSS) SAR_DRIVE scale=512
I_final59 (SampleN4 Sample VDD VSS) SAR_DRIVE scale=512
I_final60 (SampleN4 Sample VDD VSS) SAR_DRIVE scale=512
I_final61 (SampleN4 Sample VDD VSS) SAR_DRIVE scale=512
I_final62 (SampleN4 Sample VDD VSS) SAR_DRIVE scale=512
I_final63 (SampleN4 Sample VDD VSS) SAR_DRIVE scale=512
ends SAR_PHASE
