simulator lang=spectre
include "../../../../support/standard_cells/INVD1BWP7T/netlist/netlist.scs"
include "../../../../support/standard_cells/INVD2BWP7T/netlist/netlist.scs"
include "../../../../support/standard_cells/ND2D1BWP7T/netlist/netlist.scs"
subckt SAR_CMP (Vp Vn ClkC Outp Outn Valid Bias VDD VSS)
Mp_input_n (Xn Vn Tail VDD) pch l=0.18u w=4u m=1 nf=1 sd=540.0n ad=1.92e-12 as=1.92e-12 pd=8.96u ps=8.96u nrd=0.0675 nrs=0.0675 sa=480.0n sb=480.0n sca=0 scb=0 scc=0
Mp_input_p (Xp Vp Tail VDD) pch l=0.18u w=4u m=1 nf=1 sd=540.0n ad=1.92e-12 as=1.92e-12 pd=8.96u ps=8.96u nrd=0.0675 nrs=0.0675 sa=480.0n sb=480.0n sca=0 scb=0 scc=0
Mp_clock (Tail ClkC BiasDrain VDD) pch l=0.18u w=6u m=1 nf=3 sd=540.0n ad=2.04e-12 as=2.04e-12 pd=10.040u ps=10.040u nrd=0.045 nrs=0.045 sa=480.0n sb=480.0n sca=0 scb=0 scc=0
Mp_bias (BiasDrain Bias VDD VDD) pch l=0.36u w=6u m=1 nf=3 sd=540.0n ad=2.04e-12 as=2.04e-12 pd=10.040u ps=10.040u nrd=0.045 nrs=0.045 sa=480.0n sb=480.0n sca=0 scb=0 scc=0
Mn_reset_n (Xn ClkC VSS VSS) nch l=0.18u w=1u m=1 nf=1 sd=540.0n ad=4.8e-13 as=4.8e-13 pd=2.96u ps=2.96u nrd=0.27 nrs=0.27 sa=480.0n sb=480.0n sca=0 scb=0 scc=0
Mn_reset_p (Xp ClkC VSS VSS) nch l=0.18u w=1u m=1 nf=1 sd=540.0n ad=4.8e-13 as=4.8e-13 pd=2.96u ps=2.96u nrd=0.27 nrs=0.27 sa=480.0n sb=480.0n sca=0 scb=0 scc=0
Mn_latch_n (Xn Xp VSS VSS) nch l=0.18u w=2u m=1 nf=1 sd=540.0n ad=9.6e-13 as=9.6e-13 pd=4.96u ps=4.96u nrd=0.135 nrs=0.135 sa=480.0n sb=480.0n sca=0 scb=0 scc=0
Mn_latch_p (Xp Xn VSS VSS) nch l=0.18u w=2u m=1 nf=1 sd=540.0n ad=9.6e-13 as=9.6e-13 pd=4.96u ps=4.96u nrd=0.135 nrs=0.135 sa=480.0n sb=480.0n sca=0 scb=0 scc=0
I_valid (Np0 Nn0 ValidRaw VDD VSS) ND2D1BWP7T
I_out2\<1\> (Np1 Outp VDD VSS) INVD2BWP7T
I_out2\<0\> (Nn1 Outn VDD VSS) INVD2BWP7T
I_out1\<1\> (Np0 Np1 VDD VSS) INVD2BWP7T
I_out1\<0\> (Nn0 Nn1 VDD VSS) INVD2BWP7T
I_vb1 (ValidB Valid VDD VSS) INVD2BWP7T
I_vb0 (ValidRaw ValidB VDD VSS) INVD2BWP7T
I_out\<1\> (Xp Np0 VDD VSS) INVD1BWP7T
I_out\<0\> (Xn Nn0 VDD VSS) INVD1BWP7T
ends SAR_CMP
