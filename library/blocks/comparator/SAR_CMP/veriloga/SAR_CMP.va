`include "constants.vams"
`include "disciplines.vams"
module SAR_CMP_va(Vp,Vn,ClkC,Outp,Outn,Valid,Bias,VDD,VSS);
input Vp,Vn,ClkC,Bias,VDD,VSS;output Outp,Outn,Valid;
electrical Vp,Vn,ClkC,Outp,Outn,Valid,Bias,VDD,VSS;
parameter real tcompare=200p;
integer p,n,v,pending;
real completion;
analog begin
 @(initial_step) begin p=1;n=1;v=0;pending=0;completion=1e9;end
 @(cross(V(ClkC,VSS)-0.9,+1)) begin p=1;n=1;v=0;pending=0;end
 @(cross(V(ClkC,VSS)-0.9,-1)) begin pending=1;completion=$abstime+tcompare;end
 @(timer(completion)) begin
   if(pending && V(ClkC,VSS)<0.9) begin
     p=(V(Vp,Vn)>=0);n=1-p;v=1;pending=0;
   end
 end
 V(Outp,VSS)<+transition(p*1.8,0,1p,1p);
 V(Outn,VSS)<+transition(n*1.8,0,1p,1p);
 V(Valid,VSS)<+transition(v*1.8,0,1p,1p);
end
endmodule
