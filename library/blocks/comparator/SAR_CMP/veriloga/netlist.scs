ahdl_include "SAR_CMP.va"
subckt SAR_CMP (Vp Vn ClkC Outp Outn Valid Bias VDD VSS)
I_model (Vp Vn ClkC Outp Outn Valid Bias VDD VSS) SAR_CMP_va
ends SAR_CMP
