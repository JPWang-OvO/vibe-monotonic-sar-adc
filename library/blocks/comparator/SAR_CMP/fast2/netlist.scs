simulator lang=spectre
// MOS D G S B; Spectre W = CDF wf = total width; CDF w = W/nf.
include "../../../logic/SAR_INV_SMALL/transistor/netlist.scs"
include "../../../logic/SAR_NAND2/transistor/netlist.scs"
include "../../../logic/SAR_DRIVE/transistor/netlist.scs"
subckt SAR_CMP (Vp Vn ClkC Outp Outn Valid Bias VDD VSS)
Mp_bias (BiasDrain Bias VDD VDD) pch w=16u l=0.36u nf=2 m=1
Mp_clock (Tail ClkC BiasDrain VDD) pch w=16u l=0.18u nf=4 m=1
Mp_input_p (Xp Vp Tail VDD) pch w=8u l=0.18u nf=2 m=1
Mp_input_n (Xn Vn Tail VDD) pch w=8u l=0.18u nf=2 m=1
Mn_latch_p (Xp Xn VSS VSS) nch w=4u l=0.18u nf=1 m=1
Mn_latch_n (Xn Xp VSS VSS) nch w=4u l=0.18u nf=1 m=1
Mn_reset_p (Xp ClkC VSS VSS) nch w=8u l=0.18u nf=1 m=1
Mn_reset_n (Xn ClkC VSS VSS) nch w=8u l=0.18u nf=1 m=1
I_outp (Xp Outp VDD VSS) SAR_INV_SMALL
I_outn (Xn Outn VDD VSS) SAR_INV_SMALL
I_valid (Outp Outn ValidRaw VDD VSS) SAR_NAND2
I_vb0 (ValidRaw ValidB VDD VSS) SAR_DRIVE scale=1
I_vb1 (ValidB Valid VDD VSS) SAR_DRIVE scale=4
ends SAR_CMP
