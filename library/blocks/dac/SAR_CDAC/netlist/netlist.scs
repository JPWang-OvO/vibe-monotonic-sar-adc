simulator lang=spectre
subckt SAR_CDAC (Vp Vn Bp\<9\> Bp\<8\> Bp\<7\> Bp\<6\> Bp\<5\> Bp\<4\> Bp\<3\> Bp\<2\> Bp\<1\> Bn\<9\> Bn\<8\> Bn\<7\> Bn\<6\> Bn\<5\> Bn\<4\> Bn\<3\> Bn\<2\> Bn\<1\> VREFP VREFN)
parameters unit_cap=20f
Cp9 (Vp Bp\<9\>) capacitor c=256*unit_cap
Cp8 (Vp Bp\<8\>) capacitor c=128*unit_cap
Cp7 (Vp Bp\<7\>) capacitor c=64*unit_cap
Cp6 (Vp Bp\<6\>) capacitor c=32*unit_cap
Cp5 (Vp Bp\<5\>) capacitor c=16*unit_cap
Cp4 (Vp Bp\<4\>) capacitor c=8*unit_cap
Cp3 (Vp Bp\<3\>) capacitor c=4*unit_cap
Cp2 (Vp Bp\<2\>) capacitor c=2*unit_cap
Cp1 (Vp Bp\<1\>) capacitor c=1*unit_cap
Cp_dummy (Vp VREFP) capacitor c=unit_cap
Cn9 (Vn Bn\<9\>) capacitor c=256*unit_cap
Cn8 (Vn Bn\<8\>) capacitor c=128*unit_cap
Cn7 (Vn Bn\<7\>) capacitor c=64*unit_cap
Cn6 (Vn Bn\<6\>) capacitor c=32*unit_cap
Cn5 (Vn Bn\<5\>) capacitor c=16*unit_cap
Cn4 (Vn Bn\<4\>) capacitor c=8*unit_cap
Cn3 (Vn Bn\<3\>) capacitor c=4*unit_cap
Cn2 (Vn Bn\<2\>) capacitor c=2*unit_cap
Cn1 (Vn Bn\<1\>) capacitor c=1*unit_cap
Cn_dummy (Vn VREFP) capacitor c=unit_cap
ends SAR_CDAC
