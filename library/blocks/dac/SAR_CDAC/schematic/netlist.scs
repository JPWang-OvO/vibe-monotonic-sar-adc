simulator lang=spectre
subckt SAR_CDAC (Vp Vn Bp9 Bp8 Bp7 Bp6 Bp5 Bp4 Bp3 Bp2 Bp1 Bn9 Bn8 Bn7 Bn6 Bn5 Bn4 Bn3 Bn2 Bn1 VREFP VREFN)
parameters unit_cap=20f
Cn_dummy (Vn VREFP) capacitor c=unit_cap
Cn1 (Vn Bn1) capacitor c=1*unit_cap
Cn2 (Vn Bn2) capacitor c=2*unit_cap
Cn3 (Vn Bn3) capacitor c=4*unit_cap
Cn4 (Vn Bn4) capacitor c=8*unit_cap
Cn5 (Vn Bn5) capacitor c=16*unit_cap
Cn6 (Vn Bn6) capacitor c=32*unit_cap
Cn7 (Vn Bn7) capacitor c=64*unit_cap
Cn8 (Vn Bn8) capacitor c=128*unit_cap
Cn9 (Vn Bn9) capacitor c=256*unit_cap
Cp_dummy (Vp VREFP) capacitor c=unit_cap
Cp1 (Vp Bp1) capacitor c=1*unit_cap
Cp2 (Vp Bp2) capacitor c=2*unit_cap
Cp3 (Vp Bp3) capacitor c=4*unit_cap
Cp4 (Vp Bp4) capacitor c=8*unit_cap
Cp5 (Vp Bp5) capacitor c=16*unit_cap
Cp6 (Vp Bp6) capacitor c=32*unit_cap
Cp7 (Vp Bp7) capacitor c=64*unit_cap
Cp8 (Vp Bp8) capacitor c=128*unit_cap
Cp9 (Vp Bp9) capacitor c=256*unit_cap
ends SAR_CDAC
