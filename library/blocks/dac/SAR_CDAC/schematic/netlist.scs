simulator lang=spectre
subckt SAR_CDAC (Vp Vn Bp9 Bp8 Bp7 Bp6 Bp5 Bp4 Bp3 Bp2 Bp1 Bn9 Bn8 Bn7 Bn6 Bn5 Bn4 Bn3 Bn2 Bn1 VREFP VREFN)
parameters unit_cap=20f
C_dummy\<1\> (Vp VREFP) capacitor c=unit_cap
C_dummy\<0\> (Vn VREFP) capacitor c=unit_cap
C_weight1\<1\> (Vp Bp1) capacitor c=1*unit_cap
C_weight1\<0\> (Vn Bn1) capacitor c=1*unit_cap
C_weight2\<1\> (Vp Bp2) capacitor c=2*unit_cap
C_weight2\<0\> (Vn Bn2) capacitor c=2*unit_cap
C_weight3\<1\> (Vp Bp3) capacitor c=4*unit_cap
C_weight3\<0\> (Vn Bn3) capacitor c=4*unit_cap
C_weight4\<1\> (Vp Bp4) capacitor c=8*unit_cap
C_weight4\<0\> (Vn Bn4) capacitor c=8*unit_cap
C_weight5\<1\> (Vp Bp5) capacitor c=16*unit_cap
C_weight5\<0\> (Vn Bn5) capacitor c=16*unit_cap
C_weight6\<1\> (Vp Bp6) capacitor c=32*unit_cap
C_weight6\<0\> (Vn Bn6) capacitor c=32*unit_cap
C_weight7\<1\> (Vp Bp7) capacitor c=64*unit_cap
C_weight7\<0\> (Vn Bn7) capacitor c=64*unit_cap
C_weight8\<1\> (Vp Bp8) capacitor c=128*unit_cap
C_weight8\<0\> (Vn Bn8) capacitor c=128*unit_cap
C_weight9\<1\> (Vp Bp9) capacitor c=256*unit_cap
C_weight9\<0\> (Vn Bn9) capacitor c=256*unit_cap
ends SAR_CDAC
