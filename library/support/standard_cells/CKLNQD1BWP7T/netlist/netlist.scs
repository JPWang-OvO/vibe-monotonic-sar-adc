// Native standard_cells schematic export. MOS terminal order: D G S B.
simulator lang=spectre
subckt CKLNQD1BWP7T (TE E CP Q VDD VSS)

// standard_cells/CKLNQD1BWP7T/schematic
MI81 (net4 TE VDD VDD) pch l=180.0n w=1.37u m=1 nf=1
MU75\-M_u3 (Q net13 VDD VDD) pch l=180.0n w=1.37u m=1 nf=1
MU16 (net33 net49 net36 VDD) pch l=180.0n w=520.0n m=1 nf=1
MI85\-M_u2 (net13 net11 VDD VDD) pch l=180.0n w=850.0n m=1 nf=1
MI80\-M_u3 (net11 net33 VDD VDD) pch l=180.0n w=685.00n m=1 nf=1
MI79\-MU2 (net33 net5 net9 VDD) pch l=180.0n w=420.0n m=1 nf=1
MU82\-M_u3 (net49 net5 VDD VDD) pch l=180.0n w=685.00n m=1 nf=1
MI85\-M_u1 (net13 CP VDD VDD) pch l=180.0n w=900n m=1 nf=1
MI79\-MU1 (net9 net11 VDD VDD) pch l=180.0n w=420.0n m=1 nf=1
MU81\-M_u3 (net5 CP VDD VDD) pch l=180.0n w=685.00n m=1 nf=1
MU17 (net36 E net4 VDD) pch l=180.0n w=1.37u m=1 nf=1
MI80\-M_u2 (net11 net33 VSS VSS) nch l=180.0n w=500n m=1 nf=1
MU19 (net81 E VSS VSS) nch l=180.0n w=500n m=1 nf=1
MI79\-MU4 (net56 net11 VSS VSS) nch l=180.0n w=420.0n m=1 nf=1
MU20 (net81 TE VSS VSS) nch l=180.0n w=500n m=1 nf=1
MI85\-M_u4 (net69 net11 VSS VSS) nch l=180.0n w=500n m=1 nf=1
MI85\-M_u3 (net13 CP net69 VSS) nch l=180.0n w=500n m=1 nf=1
MI82 (net33 net5 net81 VSS) nch l=180.0n w=500n m=1 nf=1
MU81\-M_u2 (net5 CP VSS VSS) nch l=180.0n w=500n m=1 nf=1
MI79\-MU3 (net33 net49 net56 VSS) nch l=180.0n w=420.0n m=1 nf=1
MU82\-M_u2 (net49 net5 VSS VSS) nch l=180.0n w=500n m=1 nf=1
MU75\-M_u2 (Q net13 VSS VSS) nch l=180.0n w=525.00n m=1 nf=1

ends CKLNQD1BWP7T
