simulator lang=spectre
subckt INVD8BWP7T (I ZN VDD VSS)
MU1\-M_u2 (ZN I VSS VSS) nch l=180.0n w=8u m=1 nf=1 sd=540.0n ad=3.84e-12 as=3.84e-12 pd=16.96u ps=16.96u nrd=0.03375 nrs=0.03375 sa=480.0n sb=480.0n sca=0 scb=0 scc=0
MU1\-M_u3 (ZN I VDD VDD) pch l=180.0n w=10.96u m=1 nf=1 sd=540.0n ad=5.2608e-12 as=5.2608e-12 pd=22.88u ps=22.88u nrd=0.024635 nrs=0.024635 sa=480.0n sb=480.0n sca=0 scb=0 scc=0
ends INVD8BWP7T
