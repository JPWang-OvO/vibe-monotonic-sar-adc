// Native standard_cells schematic export. MOS terminal order: D G S B.
simulator lang=spectre
subckt DEL0BWP7T (I Z VDD VSS)

// standard_cells/DEL0BWP7T/schematic
MU7\-M_u2 (net11 net27 VSS VSS) nch l=280.0n w=700n m=1 nf=1
MI2\-M_u2 (Z net11 VSS VSS) nch l=180.0n w=1u m=1 nf=1
MI1\-M_u2 (net5 I VSS VSS) nch l=180.0n w=500n m=1 nf=1
MU5\-M_u2 (net27 net5 VSS VSS) nch l=280.0n w=670.0n m=1 nf=1
MI2\-M_u3 (Z net11 VDD VDD) pch l=180.0n w=1.37u m=1 nf=1
MU7\-M_u3 (net11 net27 VDD VDD) pch l=280.0n w=900n m=1 nf=1
MU5\-M_u3 (net27 net5 VDD VDD) pch l=280.0n w=790.0n m=1 nf=1
MI1\-M_u3 (net5 I VDD VDD) pch l=180.0n w=685.00n m=1 nf=1

ends DEL0BWP7T
