// Native standard_cells schematic export. MOS terminal order: D G S B.
simulator lang=spectre
subckt NR3D1BWP7T (A1 A2 A3 ZN VDD VSS)

// standard_cells/NR3D1BWP7T/schematic
MI3 (ZN A1 VSS VSS) nch l=180.0n w=1u m=1 nf=1
M_u4 (ZN A3 VSS VSS) nch l=180.0n w=1u m=1 nf=1
MI2 (ZN A2 VSS VSS) nch l=180.0n w=1u m=1 nf=1
M_u1_0 (net33 A3 VDD VDD) pch l=180.0n w=1.37u m=1 nf=1
MI1_0 (ZN A1 net25 VDD) pch l=180.0n w=1.37u m=1 nf=1
MI0_0 (net25 A2 net33 VDD) pch l=180.0n w=1.37u m=1 nf=1
MI1_1 (ZN A1 net24 VDD) pch l=180.0n w=1.37u m=1 nf=1
MI0_1 (net24 A2 net20 VDD) pch l=180.0n w=1.37u m=1 nf=1
M_u1_1 (net20 A3 VDD VDD) pch l=180.0n w=1.37u m=1 nf=1

ends NR3D1BWP7T
