// Native standard_cells schematic export. MOS terminal order: D G S B.
simulator lang=spectre
subckt AOI211D2BWP7T (A1 A2 B C ZN VDD VSS)

// standard_cells/AOI211D2BWP7T/schematic
MI19\-MI12 (net5 B net32 VDD) pch l=180.0n w=1.37u m=1 nf=1
MI2\-MI12 (net5 B net9 VDD) pch l=180.0n w=1.37u m=1 nf=1
MI19\-MI13 (net32 C VDD VDD) pch l=180.0n w=1.37u m=1 nf=1
M_u2_1 (net5 A2 ZN VDD) pch l=180.0n w=1.37u m=1 nf=1
M_u3_1 (net5 A1 ZN VDD) pch l=180.0n w=1.37u m=1 nf=1
MI2\-MI13 (net9 C VDD VDD) pch l=180.0n w=1.37u m=1 nf=1
M_u2_0 (net5 A2 ZN VDD) pch l=180.0n w=1.37u m=1 nf=1
M_u3_0 (net5 A1 ZN VDD) pch l=180.0n w=1.37u m=1 nf=1
MI17_1\-M_u10 (ZN A1 net37 VSS) nch l=180.0n w=1u m=1 nf=1
MI17_0\-M_u11 (net56 A2 VSS VSS) nch l=180.0n w=1u m=1 nf=1
MI17_0\-M_u10 (ZN A1 net56 VSS) nch l=180.0n w=1u m=1 nf=1
M_u12_1 (ZN C VSS VSS) nch l=180.0n w=1u m=1 nf=1
M_u12_0 (ZN C VSS VSS) nch l=180.0n w=1u m=1 nf=1
M_u13_0 (ZN B VSS VSS) nch l=180.0n w=1u m=1 nf=1
MI17_1\-M_u11 (net37 A2 VSS VSS) nch l=180.0n w=1u m=1 nf=1
M_u13_1 (ZN B VSS VSS) nch l=180.0n w=1u m=1 nf=1

ends AOI211D2BWP7T
