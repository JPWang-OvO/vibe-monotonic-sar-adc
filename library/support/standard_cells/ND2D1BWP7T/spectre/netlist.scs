// Native standard_cells schematic export. MOS terminal order: D G S B.
simulator lang=spectre
subckt ND2D1BWP7T (A1 A2 ZN VDD VSS)

// standard_cells/ND2D1BWP7T/schematic
MI1\-M_u4 (net5 A2 VSS VSS) nch l=180.0n w=1u m=1 nf=1
MI1\-M_u3 (ZN A1 net5 VSS) nch l=180.0n w=1u m=1 nf=1
MI1\-M_u1 (ZN A1 VDD VDD) pch l=180.0n w=1.37u m=1 nf=1
MI1\-M_u2 (ZN A2 VDD VDD) pch l=180.0n w=1.37u m=1 nf=1

ends ND2D1BWP7T
