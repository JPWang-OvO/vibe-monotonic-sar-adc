// Native standard_cells schematic export. MOS terminal order: D G S B.
simulator lang=spectre
subckt AOI211D1BWP7T (A1 A2 B C ZN VDD VSS)

// standard_cells/AOI211D1BWP7T/schematic
MI17\-M_u10 (ZN A1 net5 VSS) nch l=180.0n w=1u m=1 nf=1
M_u12 (ZN C VSS VSS) nch l=180.0n w=1u m=1 nf=1
MI17\-M_u11 (net5 A2 VSS VSS) nch l=180.0n w=1u m=1 nf=1
M_u13 (ZN B VSS VSS) nch l=180.0n w=1u m=1 nf=1
MI19\-MI12 (net25 B net32 VDD) pch l=180.0n w=1.37u m=1 nf=1
M_u3 (net25 A1 ZN VDD) pch l=180.0n w=1.37u m=1 nf=1
MI19\-MI13 (net32 C VDD VDD) pch l=180.0n w=1.37u m=1 nf=1
M_u2 (net25 A2 ZN VDD) pch l=180.0n w=1.37u m=1 nf=1

ends AOI211D1BWP7T
