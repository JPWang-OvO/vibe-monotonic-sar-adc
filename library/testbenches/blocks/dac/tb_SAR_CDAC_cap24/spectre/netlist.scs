simulator lang=spectre
@MODEL_SETUP@
include "../../../../../blocks/comparator/SAR_CMP/transistor/netlist.scs"
include "../../../../../blocks/bias/SAR_BIAS/transistor/netlist.scs"
include "../../../../../blocks/frontend/SAR_FRONTEND/transistor/netlist.scs"
VDD_SRC (VDD 0) vsource type=pwl wave=[0 0 10n 1.8]
Vref (Ref 0) vsource dc=1.8
Vs (Sample 0) vsource type=pulse val0=0 val1=1.8 delay=20n rise=20p fall=20p width=3.98n period=40n
Vsb (SampleB 0) vsource type=pulse val0=1.8 val1=0 delay=20n rise=20p fall=20p width=3.98n period=40n
Vinp (Vinp 0) vsource type=pwl wave=[0 0.1 1.8e-08 0.1 1.802e-08 0.1 5.8e-08 0.1 5.802e-08 0.5 9.8e-08 0.5 9.802e-08 0.9 1.38e-07 0.9 1.3802e-07 1.3 1.78e-07 1.3 1.7802e-07 1.7]
Vbp9 (Bp9 0) vsource type=pwl wave=[0 1.8 2e-08 1.8 2.002e-08 1.8 2.5e-08 1.8 2.502e-08 1.8 6e-08 1.8 6.002e-08 1.8 6.5e-08 1.8 6.502e-08 1.8 1e-07 1.8 1.0002e-07 1.8 1.05e-07 1.8 1.0502e-07 0 1.4e-07 0 1.4002e-07 1.8 1.45e-07 1.8 1.4502e-07 0 1.8e-07 0 1.8002e-07 1.8 1.85e-07 1.8 1.8502e-07 0]
Vbp8 (Bp8 0) vsource type=pwl wave=[0 1.8 2e-08 1.8 2.002e-08 1.8 2.6e-08 1.8 2.602e-08 1.8 6e-08 1.8 6.002e-08 1.8 6.6e-08 1.8 6.602e-08 0 1e-07 0 1.0002e-07 1.8 1.06e-07 1.8 1.0602e-07 1.8 1.4e-07 1.8 1.4002e-07 1.8 1.46e-07 1.8 1.4602e-07 1.8 1.8e-07 1.8 1.8002e-07 1.8 1.86e-07 1.8 1.8602e-07 0]
Vbp7 (Bp7 0) vsource type=pwl wave=[0 1.8 2e-08 1.8 2.002e-08 1.8 2.7e-08 1.8 2.702e-08 1.8 6e-08 1.8 6.002e-08 1.8 6.7e-08 1.8 6.702e-08 1.8 1e-07 1.8 1.0002e-07 1.8 1.07e-07 1.8 1.0702e-07 1.8 1.4e-07 1.8 1.4002e-07 1.8 1.47e-07 1.8 1.4702e-07 0 1.8e-07 0 1.8002e-07 1.8 1.87e-07 1.8 1.8702e-07 0]
Vbp6 (Bp6 0) vsource type=pwl wave=[0 1.8 2e-08 1.8 2.002e-08 1.8 2.8e-08 1.8 2.802e-08 1.8 6e-08 1.8 6.002e-08 1.8 6.8e-08 1.8 6.802e-08 1.8 1e-07 1.8 1.0002e-07 1.8 1.08e-07 1.8 1.0802e-07 1.8 1.4e-07 1.8 1.4002e-07 1.8 1.48e-07 1.8 1.4802e-07 0 1.8e-07 0 1.8002e-07 1.8 1.88e-07 1.8 1.8802e-07 0]
Vbp5 (Bp5 0) vsource type=pwl wave=[0 1.8 2e-08 1.8 2.002e-08 1.8 2.9e-08 1.8 2.902e-08 0 6e-08 0 6.002e-08 1.8 6.9e-08 1.8 6.902e-08 1.8 1e-07 1.8 1.0002e-07 1.8 1.09e-07 1.8 1.0902e-07 1.8 1.4e-07 1.8 1.4002e-07 1.8 1.49e-07 1.8 1.4902e-07 0 1.8e-07 0 1.8002e-07 1.8 1.89e-07 1.8 1.8902e-07 1.8]
Vbp4 (Bp4 0) vsource type=pwl wave=[0 1.8 2e-08 1.8 2.002e-08 1.8 3e-08 1.8 3.002e-08 0 6e-08 0 6.002e-08 1.8 7e-08 1.8 7.002e-08 0 1e-07 0 1.0002e-07 1.8 1.1e-07 1.8 1.1002e-07 1.8 1.4e-07 1.8 1.4002e-07 1.8 1.5e-07 1.8 1.5002e-07 1.8 1.8e-07 1.8 1.8002e-07 1.8 1.9e-07 1.8 1.9002e-07 1.8]
Vbp3 (Bp3 0) vsource type=pwl wave=[0 1.8 2e-08 1.8 2.002e-08 1.8 3.1e-08 1.8 3.102e-08 0 6e-08 0 6.002e-08 1.8 7.1e-08 1.8 7.102e-08 0 1e-07 0 1.0002e-07 1.8 1.11e-07 1.8 1.1102e-07 1.8 1.4e-07 1.8 1.4002e-07 1.8 1.51e-07 1.8 1.5102e-07 1.8 1.8e-07 1.8 1.8002e-07 1.8 1.91e-07 1.8 1.9102e-07 1.8]
Vbp2 (Bp2 0) vsource type=pwl wave=[0 1.8 2e-08 1.8 2.002e-08 1.8 3.2e-08 1.8 3.202e-08 1.8 6e-08 1.8 6.002e-08 1.8 7.2e-08 1.8 7.202e-08 0 1e-07 0 1.0002e-07 1.8 1.12e-07 1.8 1.1202e-07 1.8 1.4e-07 1.8 1.4002e-07 1.8 1.52e-07 1.8 1.5202e-07 1.8 1.8e-07 1.8 1.8002e-07 1.8 1.92e-07 1.8 1.9202e-07 0]
Vbp1 (Bp1 0) vsource type=pwl wave=[0 1.8 2e-08 1.8 2.002e-08 1.8 3.3e-08 1.8 3.302e-08 1.8 6e-08 1.8 6.002e-08 1.8 7.3e-08 1.8 7.302e-08 1.8 1e-07 1.8 1.0002e-07 1.8 1.13e-07 1.8 1.1302e-07 1.8 1.4e-07 1.8 1.4002e-07 1.8 1.53e-07 1.8 1.5302e-07 0 1.8e-07 0 1.8002e-07 1.8 1.93e-07 1.8 1.9302e-07 0]
Vinn (Vinn 0) vsource type=pwl wave=[0 1.7 1.8e-08 1.7 1.802e-08 1.7 5.8e-08 1.7 5.802e-08 1.3 9.8e-08 1.3 9.802e-08 0.9 1.38e-07 0.9 1.3802e-07 0.5 1.78e-07 0.5 1.7802e-07 0.1]
Vbn9 (Bn9 0) vsource type=pwl wave=[0 1.8 2e-08 1.8 2.002e-08 1.8 2.5e-08 1.8 2.502e-08 0 6e-08 0 6.002e-08 1.8 6.5e-08 1.8 6.502e-08 0 1e-07 0 1.0002e-07 1.8 1.05e-07 1.8 1.0502e-07 1.8 1.4e-07 1.8 1.4002e-07 1.8 1.45e-07 1.8 1.4502e-07 1.8 1.8e-07 1.8 1.8002e-07 1.8 1.85e-07 1.8 1.8502e-07 1.8]
Vbn8 (Bn8 0) vsource type=pwl wave=[0 1.8 2e-08 1.8 2.002e-08 1.8 2.6e-08 1.8 2.602e-08 0 6e-08 0 6.002e-08 1.8 6.6e-08 1.8 6.602e-08 1.8 1e-07 1.8 1.0002e-07 1.8 1.06e-07 1.8 1.0602e-07 0 1.4e-07 0 1.4002e-07 1.8 1.46e-07 1.8 1.4602e-07 0 1.8e-07 0 1.8002e-07 1.8 1.86e-07 1.8 1.8602e-07 1.8]
Vbn7 (Bn7 0) vsource type=pwl wave=[0 1.8 2e-08 1.8 2.002e-08 1.8 2.7e-08 1.8 2.702e-08 0 6e-08 0 6.002e-08 1.8 6.7e-08 1.8 6.702e-08 0 1e-07 0 1.0002e-07 1.8 1.07e-07 1.8 1.0702e-07 0 1.4e-07 0 1.4002e-07 1.8 1.47e-07 1.8 1.4702e-07 1.8 1.8e-07 1.8 1.8002e-07 1.8 1.87e-07 1.8 1.8702e-07 1.8]
Vbn6 (Bn6 0) vsource type=pwl wave=[0 1.8 2e-08 1.8 2.002e-08 1.8 2.8e-08 1.8 2.802e-08 0 6e-08 0 6.002e-08 1.8 6.8e-08 1.8 6.802e-08 0 1e-07 0 1.0002e-07 1.8 1.08e-07 1.8 1.0802e-07 0 1.4e-07 0 1.4002e-07 1.8 1.48e-07 1.8 1.4802e-07 1.8 1.8e-07 1.8 1.8002e-07 1.8 1.88e-07 1.8 1.8802e-07 1.8]
Vbn5 (Bn5 0) vsource type=pwl wave=[0 1.8 2e-08 1.8 2.002e-08 1.8 2.9e-08 1.8 2.902e-08 1.8 6e-08 1.8 6.002e-08 1.8 6.9e-08 1.8 6.902e-08 0 1e-07 0 1.0002e-07 1.8 1.09e-07 1.8 1.0902e-07 0 1.4e-07 0 1.4002e-07 1.8 1.49e-07 1.8 1.4902e-07 1.8 1.8e-07 1.8 1.8002e-07 1.8 1.89e-07 1.8 1.8902e-07 0]
Vbn4 (Bn4 0) vsource type=pwl wave=[0 1.8 2e-08 1.8 2.002e-08 1.8 3e-08 1.8 3.002e-08 1.8 6e-08 1.8 6.002e-08 1.8 7e-08 1.8 7.002e-08 1.8 1e-07 1.8 1.0002e-07 1.8 1.1e-07 1.8 1.1002e-07 0 1.4e-07 0 1.4002e-07 1.8 1.5e-07 1.8 1.5002e-07 0 1.8e-07 0 1.8002e-07 1.8 1.9e-07 1.8 1.9002e-07 0]
Vbn3 (Bn3 0) vsource type=pwl wave=[0 1.8 2e-08 1.8 2.002e-08 1.8 3.1e-08 1.8 3.102e-08 1.8 6e-08 1.8 6.002e-08 1.8 7.1e-08 1.8 7.102e-08 1.8 1e-07 1.8 1.0002e-07 1.8 1.11e-07 1.8 1.1102e-07 0 1.4e-07 0 1.4002e-07 1.8 1.51e-07 1.8 1.5102e-07 0 1.8e-07 0 1.8002e-07 1.8 1.91e-07 1.8 1.9102e-07 0]
Vbn2 (Bn2 0) vsource type=pwl wave=[0 1.8 2e-08 1.8 2.002e-08 1.8 3.2e-08 1.8 3.202e-08 0 6e-08 0 6.002e-08 1.8 7.2e-08 1.8 7.202e-08 1.8 1e-07 1.8 1.0002e-07 1.8 1.12e-07 1.8 1.1202e-07 0 1.4e-07 0 1.4002e-07 1.8 1.52e-07 1.8 1.5202e-07 0 1.8e-07 0 1.8002e-07 1.8 1.92e-07 1.8 1.9202e-07 1.8]
Vbn1 (Bn1 0) vsource type=pwl wave=[0 1.8 2e-08 1.8 2.002e-08 1.8 3.3e-08 1.8 3.302e-08 0 6e-08 0 6.002e-08 1.8 7.3e-08 1.8 7.302e-08 0 1e-07 0 1.0002e-07 1.8 1.13e-07 1.8 1.1302e-07 0 1.4e-07 0 1.4002e-07 1.8 1.53e-07 1.8 1.5302e-07 1.8 1.8e-07 1.8 1.8002e-07 1.8 1.93e-07 1.8 1.9302e-07 1.8]
I_front (Vinp Vinn Sample SampleB Vp Vn Bp9 Bp8 Bp7 Bp6 Bp5 Bp4 Bp3 Bp2 Bp1 Bn9 Bn8 Bn7 Bn6 Bn5 Bn4 Bn3 Bn2 Bn1 Ref 0 VDD 0) SAR_FRONTEND unit_cap=@CUNIT@ ccross=28f
Vclk (ClkC 0) vsource dc=1.8
I_bias (Bias VDD 0) SAR_BIAS
I_cmp (Vp Vn ClkC Outp Outn Valid Bias VDD 0) SAR_CMP
CLp (Outp 0) capacitor c=50f
CLn (Outn 0) capacitor c=10f
CLv (Valid 0) capacitor c=100f
simulatorOptions options temp=@TEMP@
tran tran stop=199n
saveOptions options save=selected
save Sample SampleB Vinp Vinn Vp Vn I_front.Gp I_front.Gn VDD_SRC:p
