simulator lang=spectre
@MODEL_SETUP@
include "../../../../../blocks/sampling/SAR_SAMPLE/transistor/netlist.scs"
include "../../../../../blocks/clock/SAR_PHASE/transistor/netlist.scs"
include "../../../../../blocks/logic/SAR_INV/transistor/netlist.scs"
VDD_SRC (VDD 0) vsource type=pwl wave=[0 0 10n 1.8]
Vref (Ref 0) vsource dc=1.8
VinP (Vinp 0) vsource type=sine dc=0.9 ampl=0.802125844320371 freq=@FIN@
VinN (Vinn 0) vsource type=sine dc=0.9 ampl=-0.802125844320371 freq=@FIN@
Vclock (Clks 0) vsource type=pulse val0=0 val1=1.8 delay=20n rise=20p fall=20p width=1.98n period=4n
I_phase (Clks Sample VDD 0) SAR_PHASE
I_inv (Sample SampleB VDD 0) SAR_INV
I_sp (Vinp Vp Sample SampleB Gp VDD 0) SAR_SAMPLE
I_sn (Vinn Vn Sample SampleB Gn VDD 0) SAR_SAMPLE
Ccomp_p (Gp Vn) capacitor c=@CCOMP@
Ccomp_n (Gn Vp) capacitor c=@CCOMP@
Cp (Vp Ref) capacitor c=@CLOAD@
Cn (Vn Ref) capacitor c=@CLOAD@
simulatorOptions options temp=@TEMP@
tran tran stop=5.80u
saveOptions options save=selected
save Sample SampleB Clks Vinp Vinn Vp Vn Gp Gn VDD_SRC:p
