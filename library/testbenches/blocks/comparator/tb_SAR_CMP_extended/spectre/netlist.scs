simulator lang=spectre
@MODEL_SETUP@
include "../../../../../blocks/comparator/SAR_CMP/transistor/netlist.scs"
include "../../../../../blocks/bias/SAR_BIAS/transistor/netlist.scs"
VDD_SRC (VDD 0) vsource type=pwl wave=[0 0 10n 1.8]
Vclock (ClkC 0) vsource type=pulse val0=1.8 val1=0 delay=52n rise=20p fall=20p width=3.98n period=10n
Vinp (Vp 0) vsource type=pwl wave=[0 0.900439453125 5e-08 0.900439453125 5.002e-08 0.900439453125 6e-08 0.900439453125 6.002e-08 0.899560546875 7e-08 0.899560546875 7.002e-08 0.9017578125 8e-08 0.9017578125 8.002e-08 0.8982421875 9e-08 0.8982421875 9.002e-08 0.450439453125 1e-07 0.450439453125 1.0002e-07 0.449560546875 1.1e-07 0.449560546875 1.1002e-07 0.4517578125 1.2e-07 0.4517578125 1.2002e-07 0.4482421875 1.3e-07 0.4482421875 1.3002e-07 0.112939453125 1.4e-07 0.112939453125 1.4002e-07 0.112060546875 1.5e-07 0.112060546875 1.5002e-07 0.1142578125 1.6e-07 0.1142578125 1.6002e-07 0.1107421875 1.7e-07 0.1107421875 1.7002e-07 0.014501953125 1.8e-07 0.014501953125 1.8002e-07 0.013623046875 1.9e-07 0.013623046875 1.9002e-07 0.0158203125 2e-07 0.0158203125 2.0002e-07 0.0123046875 2.1e-07 0.0123046875 2.1002e-07 0.002197265625 2.2e-07 0.002197265625 2.2002e-07 0.001318359375 2.3e-07 0.001318359375 2.3002e-07 0.003515625 2.4e-07 0.003515625 2.4002e-07 0 2.5e-07 0 2.5002e-07 -0.079560546875 2.6e-07 -0.079560546875 2.6002e-07 -0.080439453125 2.7e-07 -0.080439453125 2.7002e-07 -0.0782421875 2.8e-07 -0.0782421875 2.8002e-07 -0.0817578125]
Vinn (Vn 0) vsource type=pwl wave=[0 0.899560546875 5e-08 0.899560546875 5.002e-08 0.899560546875 6e-08 0.899560546875 6.002e-08 0.900439453125 7e-08 0.900439453125 7.002e-08 0.8982421875 8e-08 0.8982421875 8.002e-08 0.9017578125 9e-08 0.9017578125 9.002e-08 0.449560546875 1e-07 0.449560546875 1.0002e-07 0.450439453125 1.1e-07 0.450439453125 1.1002e-07 0.4482421875 1.2e-07 0.4482421875 1.2002e-07 0.4517578125 1.3e-07 0.4517578125 1.3002e-07 0.112060546875 1.4e-07 0.112060546875 1.4002e-07 0.112939453125 1.5e-07 0.112939453125 1.5002e-07 0.1107421875 1.6e-07 0.1107421875 1.6002e-07 0.1142578125 1.7e-07 0.1142578125 1.7002e-07 0.013623046875 1.8e-07 0.013623046875 1.8002e-07 0.014501953125 1.9e-07 0.014501953125 1.9002e-07 0.0123046875 2e-07 0.0123046875 2.0002e-07 0.0158203125 2.1e-07 0.0158203125 2.1002e-07 0.001318359375 2.2e-07 0.001318359375 2.2002e-07 0.002197265625 2.3e-07 0.002197265625 2.3002e-07 0 2.4e-07 0 2.4002e-07 0.003515625 2.5e-07 0.003515625 2.5002e-07 -0.080439453125 2.6e-07 -0.080439453125 2.6002e-07 -0.079560546875 2.7e-07 -0.079560546875 2.7002e-07 -0.0817578125 2.8e-07 -0.0817578125 2.8002e-07 -0.0782421875]
I_bias (Bias VDD 0) SAR_BIAS
I_cmp (Vp Vn ClkC Outp Outn Valid Bias VDD 0) SAR_CMP
CLp (Outp 0) capacitor c=20f
CLn (Outn 0) capacitor c=20f
CLv (Valid 0) capacitor c=50f
simulatorOptions options temp=@TEMP@
tran tran stop=292n
saveOptions options save=selected
save Vp Vn ClkC Outp Outn Valid Bias I_cmp.Xp I_cmp.Xn I_cmp.Tail I_cmp.BiasDrain VDD_SRC:p
