simulator lang=spectre
@MODEL_SETUP@
include "../../../../../blocks/comparator/SAR_CMP/netlist/netlist.scs"
include "../../../../../blocks/bias/SAR_BIAS/netlist/netlist.scs"
VDD_SRC (VDD 0) vsource type=pwl wave=[0 0 10n 1.8]
Vclock (ClkC 0) vsource type=pulse val0=1.8 val1=0 delay=120n rise=20p fall=20p width=1.98n period=4n
Vinp (Vp 0) vsource type=pwl wave=[0 0.9 1.19e-07 0.9 1.1902e-07 0.9 1.23e-07 0.9 1.2302e-07 0.8995 1.27e-07 0.8995 1.2702e-07 0.90025 1.31e-07 0.90025 1.3102e-07 0.9005 1.35e-07 0.9005 1.3502e-07 0.899 1.39e-07 0.899 \
1.3902e-07 0.89975 1.43e-07 0.89975 1.4302e-07 0.9015 1.47e-07 0.9015 1.4702e-07 0.901 1.51e-07 0.901 1.5102e-07 0.8985 1.55e-07 0.8985 1.5502e-07 0.9 1.59e-07 0.9 1.5902e-07 0.901 1.63e-07 0.901 \
1.6302e-07 0.8995 1.67e-07 0.8995 1.6702e-07 0.8985 1.71e-07 0.8985 1.7102e-07 0.9005 1.75e-07 0.9005 1.7502e-07 0.899 1.79e-07 0.899 1.7902e-07 0.90025 1.83e-07 0.90025 1.8302e-07 0.89975 1.87e-07 0.89975 \
1.8702e-07 0.9015 1.91e-07 0.9015 1.9102e-07 0.899 1.95e-07 0.899 1.9502e-07 0.9015 1.99e-07 0.9015 1.9902e-07 0.8985 2.03e-07 0.8985 2.0302e-07 0.9005 2.07e-07 0.9005 2.0702e-07 0.901 2.11e-07 0.901 \
2.1102e-07 0.90025 2.15e-07 0.90025 2.1502e-07 0.9 2.19e-07 0.9 2.1902e-07 0.89975 2.23e-07 0.89975 2.2302e-07 0.8995 2.27e-07 0.8995 2.2702e-07 0.9 2.31e-07 0.9 2.3102e-07 0.90025 2.35e-07 0.90025 \
2.3502e-07 0.901 2.39e-07 0.901 2.3902e-07 0.9015 2.43e-07 0.9015 2.4302e-07 0.8995 2.47e-07 0.8995 2.4702e-07 0.89975 2.51e-07 0.89975 2.5102e-07 0.9005 2.55e-07 0.9005 2.5502e-07 0.8985 2.59e-07 0.8985 \
2.5902e-07 0.899 2.63e-07 0.899 2.6302e-07 0.8995 2.67e-07 0.8995 2.6702e-07 0.8985 2.71e-07 0.8985 2.7102e-07 0.89975 2.75e-07 0.89975 2.7502e-07 0.9015 2.79e-07 0.9015 2.7902e-07 0.901 2.83e-07 0.901 \
2.8302e-07 0.899 2.87e-07 0.899 2.8702e-07 0.9 2.91e-07 0.9 2.9102e-07 0.90025 2.95e-07 0.90025 2.9502e-07 0.9005 2.99e-07 0.9005 2.9902e-07 0.9005 3.03e-07 0.9005 3.0302e-07 0.9015 3.07e-07 0.9015 \
3.0702e-07 0.89975 3.11e-07 0.89975 3.1102e-07 0.9 3.15e-07 0.9 3.1502e-07 0.90025 3.19e-07 0.90025 3.1902e-07 0.899 3.23e-07 0.899 3.2302e-07 0.901 3.27e-07 0.901 3.2702e-07 0.8995 3.31e-07 0.8995 \
3.3102e-07 0.8985 3.35e-07 0.8985 3.3502e-07 0.8985 3.39e-07 0.8985 3.3902e-07 0.9 3.43e-07 0.9 3.4302e-07 0.8995 3.47e-07 0.8995 3.4702e-07 0.89975 3.51e-07 0.89975 3.5102e-07 0.9005 3.55e-07 0.9005 \
3.5502e-07 0.9015 3.59e-07 0.9015 3.5902e-07 0.90025 3.63e-07 0.90025 3.6302e-07 0.901 3.67e-07 0.901 3.6702e-07 0.899 3.71e-07 0.899 3.7102e-07 0.9 3.75e-07 0.9 3.7502e-07 0.8995 3.79e-07 0.8995 \
3.7902e-07 0.9005 3.83e-07 0.9005 3.8302e-07 0.8985 3.87e-07 0.8985 3.8702e-07 0.9015 3.91e-07 0.9015 3.9102e-07 0.899 3.95e-07 0.899 3.9502e-07 0.901 3.99e-07 0.901 3.9902e-07 0.90025 4.03e-07 0.90025 \
4.0302e-07 0.89975 4.07e-07 0.89975 4.0702e-07 0.899 4.11e-07 0.899 4.1102e-07 0.9005 4.15e-07 0.9005 4.1502e-07 0.8985 4.19e-07 0.8985 4.1902e-07 0.8995 4.23e-07 0.8995 4.2302e-07 0.901 4.27e-07 0.901 \
4.2702e-07 0.89975 4.31e-07 0.89975 4.3102e-07 0.9015 4.35e-07 0.9015 4.3502e-07 0.90025 4.39e-07 0.90025 4.3902e-07 0.9 4.43e-07 0.9 4.4302e-07 0.899 4.47e-07 0.899 4.4702e-07 0.89975 4.51e-07 0.89975 \
4.5102e-07 0.8985 4.55e-07 0.8985 4.5502e-07 0.901 4.59e-07 0.901 4.5902e-07 0.90025 4.63e-07 0.90025 4.6302e-07 0.9005 4.67e-07 0.9005 4.6702e-07 0.9015 4.71e-07 0.9015 4.7102e-07 0.8995 4.75e-07 0.8995 \
4.7502e-07 0.9 4.79e-07 0.9 4.7902e-07 0.9015 4.83e-07 0.9015 4.8302e-07 0.899 4.87e-07 0.899 4.8702e-07 0.90025 4.91e-07 0.90025 4.9102e-07 0.901 4.95e-07 0.901 4.9502e-07 0.8995 4.99e-07 0.8995 \
4.9902e-07 0.9 5.03e-07 0.9 5.0302e-07 0.9005 5.07e-07 0.9005 5.0702e-07 0.8985 5.11e-07 0.8985 5.1102e-07 0.89975 5.15e-07 0.89975 5.1502e-07 0.8995 5.19e-07 0.8995 5.1902e-07 0.9005 5.23e-07 0.9005 \
5.2302e-07 0.901 5.27e-07 0.901 5.2702e-07 0.89975 5.31e-07 0.89975 5.3102e-07 0.8985 5.35e-07 0.8985 5.3502e-07 0.899 5.39e-07 0.899 5.3902e-07 0.90025 5.43e-07 0.90025 5.4302e-07 0.9015 5.47e-07 0.9015 \
5.4702e-07 0.9 5.51e-07 0.9 5.5102e-07 0.8995 5.55e-07 0.8995 5.5502e-07 0.89975 5.59e-07 0.89975 5.5902e-07 0.899 5.63e-07 0.899 5.6302e-07 0.90025 5.67e-07 0.90025 5.6702e-07 0.9 5.71e-07 0.9 \
5.7102e-07 0.8985 5.75e-07 0.8985 5.7502e-07 0.9015 5.79e-07 0.9015 5.7902e-07 0.9005 5.83e-07 0.9005 5.8302e-07 0.901 5.87e-07 0.901 5.8702e-07 0.90025 5.91e-07 0.90025 5.9102e-07 0.8985 5.95e-07 0.8985 \
5.9502e-07 0.901 5.99e-07 0.901 5.9902e-07 0.9 6.03e-07 0.9 6.0302e-07 0.9005 6.07e-07 0.9005 6.0702e-07 0.8995 6.11e-07 0.8995 6.1102e-07 0.9015 6.15e-07 0.9015 6.1502e-07 0.89975 6.19e-07 0.89975 \
6.1902e-07 0.899 6.23e-07 0.899 6.2302e-07 0.899 6.27e-07 0.899 6.2702e-07 0.8985 6.31e-07 0.8985 6.3102e-07 0.90025 6.35e-07 0.90025 6.3502e-07 0.89975 6.39e-07 0.89975 6.3902e-07 0.9015 6.43e-07 0.9015 \
6.4302e-07 0.8995 6.47e-07 0.8995 6.4702e-07 0.9005 6.51e-07 0.9005 6.5102e-07 0.9 6.55e-07 0.9 6.5502e-07 0.901 6.59e-07 0.901 6.5902e-07 0.8995 6.63e-07 0.8995 6.6302e-07 0.9005 6.67e-07 0.9005 \
6.6702e-07 0.8985 6.71e-07 0.8985 6.7102e-07 0.89975 6.75e-07 0.89975 6.7502e-07 0.9 6.79e-07 0.9 6.7902e-07 0.90025 6.83e-07 0.90025 6.8302e-07 0.9015 6.87e-07 0.9015 6.8702e-07 0.901 6.91e-07 0.901 \
6.9102e-07 0.899 6.95e-07 0.899 6.9502e-07 0.89975 6.99e-07 0.89975 6.9902e-07 0.9005 7.03e-07 0.9005 7.0302e-07 0.90025 7.07e-07 0.90025 7.0702e-07 0.9 7.11e-07 0.9 7.1102e-07 0.8985 7.15e-07 0.8985 \
7.1502e-07 0.899 7.19e-07 0.899 7.1902e-07 0.8995 7.23e-07 0.8995 7.2302e-07 0.9015 7.27e-07 0.9015 7.2702e-07 0.901 7.31e-07 0.901 7.3102e-07 0.90025 7.35e-07 0.90025 7.3502e-07 0.89975 7.39e-07 0.89975 \
7.3902e-07 0.9015 7.43e-07 0.9015 7.4302e-07 0.9 7.47e-07 0.9 7.4702e-07 0.9005 7.51e-07 0.9005 7.5102e-07 0.899 7.55e-07 0.899 7.5502e-07 0.8985 7.59e-07 0.8985 7.5902e-07 0.8995 7.63e-07 0.8995 \
7.6302e-07 0.901 7.67e-07 0.901 7.6702e-07 0.8985 7.71e-07 0.8985 7.7102e-07 0.9005 7.75e-07 0.9005 7.7502e-07 0.8995 7.79e-07 0.8995 7.7902e-07 0.9015 7.83e-07 0.9015 7.8302e-07 0.901 7.87e-07 0.901 \
7.8702e-07 0.899 7.91e-07 0.899 7.9102e-07 0.90025 7.95e-07 0.90025 7.9502e-07 0.9 7.99e-07 0.9 7.9902e-07 0.89975 8.03e-07 0.89975 8.0302e-07 0.8985 8.07e-07 0.8985 8.0702e-07 0.899 8.11e-07 0.899 \
8.1102e-07 0.9005 8.15e-07 0.9005 8.1502e-07 0.8995 8.19e-07 0.8995 8.1902e-07 0.901 8.23e-07 0.901 8.2302e-07 0.9 8.27e-07 0.9 8.2702e-07 0.90025 8.31e-07 0.90025 8.3102e-07 0.9015 8.35e-07 0.9015 \
8.3502e-07 0.89975 8.39e-07 0.89975 8.3902e-07 0.899 8.43e-07 0.899 8.4302e-07 0.9015 8.47e-07 0.9015 8.4702e-07 0.89975 8.51e-07 0.89975 8.5102e-07 0.9005 8.55e-07 0.9005 8.5502e-07 0.9 8.59e-07 0.9 \
8.5902e-07 0.8985 8.63e-07 0.8985 8.6302e-07 0.901 8.67e-07 0.901 8.6702e-07 0.8995 8.71e-07 0.8995 8.7102e-07 0.90025 8.75e-07 0.90025 8.7502e-07 0.89975 8.79e-07 0.89975 8.7902e-07 0.90025 8.83e-07 0.90025 \
8.8302e-07 0.8995 8.87e-07 0.8995 8.8702e-07 0.901 8.91e-07 0.901 8.9102e-07 0.8985 8.95e-07 0.8985 8.9502e-07 0.899 8.99e-07 0.899 8.9902e-07 0.9015 9.03e-07 0.9015 9.0302e-07 0.9005 9.07e-07 0.9005 \
9.0702e-07 0.9 9.11e-07 0.9 9.1102e-07 0.8985 9.15e-07 0.8985 9.1502e-07 0.9 9.19e-07 0.9 9.1902e-07 0.90025 9.23e-07 0.90025 9.2302e-07 0.9005 9.27e-07 0.9005 9.2702e-07 0.901 9.31e-07 0.901 \
9.3102e-07 0.9015 9.35e-07 0.9015 9.3502e-07 0.899 9.39e-07 0.899 9.3902e-07 0.8995 9.43e-07 0.8995 9.4302e-07 0.89975 9.47e-07 0.89975 9.4702e-07 0.901 9.51e-07 0.901 9.5102e-07 0.90025 9.55e-07 0.90025 \
9.5502e-07 0.899 9.59e-07 0.899 9.5902e-07 0.9 9.63e-07 0.9 9.6302e-07 0.8985 9.67e-07 0.8985 9.6702e-07 0.8995 9.71e-07 0.8995 9.7102e-07 0.9005 9.75e-07 0.9005 9.7502e-07 0.89975 9.79e-07 0.89975 \
9.7902e-07 0.9015 9.83e-07 0.9015 9.8302e-07 0.9015 9.87e-07 0.9015 9.8702e-07 0.8985 9.91e-07 0.8985 9.9102e-07 0.9005 9.95e-07 0.9005 9.9502e-07 0.899 9.99e-07 0.899 9.9902e-07 0.8995 1.003e-06 0.8995 \
1.00302e-06 0.90025 1.007e-06 0.90025 1.00702e-06 0.901 1.011e-06 0.901 1.01102e-06 0.89975 1.015e-06 0.89975 1.01502e-06 0.9 1.019e-06 0.9 1.01902e-06 0.8985 1.023e-06 0.8985 1.02302e-06 0.8995 1.027e-06 0.8995 \
1.02702e-06 0.89975 1.031e-06 0.89975 1.03102e-06 0.9 1.035e-06 0.9 1.03502e-06 0.9015 1.039e-06 0.9015 1.03902e-06 0.899 1.043e-06 0.899 1.04302e-06 0.90025 1.047e-06 0.90025 1.04702e-06 0.9005 1.051e-06 0.9005 \
1.05102e-06 0.901 1.055e-06 0.901 1.05502e-06 0.9015 1.059e-06 0.9015 1.05902e-06 0.89975 1.063e-06 0.89975 1.06302e-06 0.8995 1.067e-06 0.8995 1.06702e-06 0.901 1.071e-06 0.901 1.07102e-06 0.9005 1.075e-06 0.9005 \
1.07502e-06 0.899 1.079e-06 0.899 1.07902e-06 0.8985 1.083e-06 0.8985 1.08302e-06 0.90025 1.087e-06 0.90025 1.08702e-06 0.9 1.091e-06 0.9 1.09102e-06 0.9 1.095e-06 0.9 1.09502e-06 0.9005 1.099e-06 0.9005 \
1.09902e-06 0.8985 1.103e-06 0.8985 1.10302e-06 0.89975 1.107e-06 0.89975 1.10702e-06 0.899 1.111e-06 0.899 1.11102e-06 0.8995 1.115e-06 0.8995 1.11502e-06 0.90025 1.119e-06 0.90025 1.11902e-06 0.9015 1.123e-06 0.9015 \
1.12302e-06 0.901 1.127e-06 0.901 1.12702e-06 0.90025 1.131e-06 0.90025 1.13102e-06 0.9005 1.135e-06 0.9005 1.13502e-06 0.899 1.139e-06 0.899 1.13902e-06 0.9 1.143e-06 0.9 1.14302e-06 0.8985 1.147e-06 0.8985 \
1.14702e-06 0.89975 1.151e-06 0.89975 1.15102e-06 0.9015 1.155e-06 0.9015 1.15502e-06 0.8995 1.159e-06 0.8995 1.15902e-06 0.901 1.163e-06 0.901 1.16302e-06 0.89975 1.167e-06 0.89975 1.16702e-06 0.8985 1.171e-06 0.8985 \
1.17102e-06 0.90025 1.175e-06 0.90025 1.17502e-06 0.9005 1.179e-06 0.9005 1.17902e-06 0.901 1.183e-06 0.901 1.18302e-06 0.899 1.187e-06 0.899 1.18702e-06 0.8995 1.191e-06 0.8995 1.19102e-06 0.9015 1.195e-06 0.9015 \
1.19502e-06 0.9 1.199e-06 0.9 1.19902e-06 0.899 1.203e-06 0.899 1.20302e-06 0.9015 1.207e-06 0.9015 1.20702e-06 0.8985 1.211e-06 0.8985 1.21102e-06 0.901 1.215e-06 0.901 1.21502e-06 0.9 1.219e-06 0.9 \
1.21902e-06 0.90025 1.223e-06 0.90025 1.22302e-06 0.9005 1.227e-06 0.9005 1.22702e-06 0.8995 1.231e-06 0.8995 1.23102e-06 0.89975 1.235e-06 0.89975 1.23502e-06 0.9015 1.239e-06 0.9015 1.23902e-06 0.899 1.243e-06 0.899 \
1.24302e-06 0.9005 1.247e-06 0.9005 1.24702e-06 0.901 1.251e-06 0.901 1.25102e-06 0.8995 1.255e-06 0.8995 1.25502e-06 0.89975 1.259e-06 0.89975 1.25902e-06 0.9 1.263e-06 0.9 1.26302e-06 0.90025 1.267e-06 0.90025 \
1.26702e-06 0.8985 1.271e-06 0.8985 1.27102e-06 0.8995 1.275e-06 0.8995 1.27502e-06 0.8985 1.279e-06 0.8985 1.27902e-06 0.901 1.283e-06 0.901 1.28302e-06 0.9015 1.287e-06 0.9015 1.28702e-06 0.899 1.291e-06 0.899 \
1.29102e-06 0.90025 1.295e-06 0.90025 1.29502e-06 0.89975 1.299e-06 0.89975 1.29902e-06 0.9005 1.303e-06 0.9005 1.30302e-06 0.9 1.307e-06 0.9 1.30702e-06 0.899 1.311e-06 0.899 1.31102e-06 0.90025 1.315e-06 0.90025 \
1.31502e-06 0.9005 1.319e-06 0.9005 1.31902e-06 0.9 1.323e-06 0.9 1.32302e-06 0.8995 1.327e-06 0.8995 1.32702e-06 0.901 1.331e-06 0.901 1.33102e-06 0.8985 1.335e-06 0.8985 1.33502e-06 0.9015 1.339e-06 0.9015 \
1.33902e-06 0.89975 1.343e-06 0.89975 1.34302e-06 0.8995 1.347e-06 0.8995 1.34702e-06 0.9 1.351e-06 0.9 1.35102e-06 0.8985 1.355e-06 0.8985 1.35502e-06 0.899 1.359e-06 0.899 1.35902e-06 0.9005 1.363e-06 0.9005 \
1.36302e-06 0.901 1.367e-06 0.901 1.36702e-06 0.9015 1.371e-06 0.9015 1.37102e-06 0.89975 1.375e-06 0.89975 1.37502e-06 0.90025 1.379e-06 0.90025 1.37902e-06 0.9015 1.383e-06 0.9015 1.38302e-06 0.901 1.387e-06 0.901 \
1.38702e-06 0.8995 1.391e-06 0.8995 1.39102e-06 0.9005 1.395e-06 0.9005 1.39502e-06 0.9 1.399e-06 0.9 1.39902e-06 0.899 1.403e-06 0.899 1.40302e-06 0.89975 1.407e-06 0.89975 1.40702e-06 0.8985 1.411e-06 0.8985 \
1.41102e-06 0.90025 1.415e-06 0.90025 1.41502e-06 0.901 1.419e-06 0.901 1.41902e-06 0.9 1.423e-06 0.9 1.42302e-06 0.9015 1.427e-06 0.9015 1.42702e-06 0.8995 1.431e-06 0.8995 1.43102e-06 0.90025 1.435e-06 0.90025 \
1.43502e-06 0.9005 1.439e-06 0.9005 1.43902e-06 0.89975 1.443e-06 0.89975 1.44302e-06 0.8985 1.447e-06 0.8985 1.44702e-06 0.899 1.451e-06 0.899 1.45102e-06 0.8995 1.455e-06 0.8995 1.45502e-06 0.9 1.459e-06 0.9 \
1.45902e-06 0.901 1.463e-06 0.901 1.46302e-06 0.89975 1.467e-06 0.89975 1.46702e-06 0.9015 1.471e-06 0.9015 1.47102e-06 0.9005 1.475e-06 0.9005 1.47502e-06 0.899 1.479e-06 0.899 1.47902e-06 0.90025 1.483e-06 0.90025 \
1.48302e-06 0.8985 1.487e-06 0.8985 1.48702e-06 0.9015 1.491e-06 0.9015 1.49102e-06 0.8995 1.495e-06 0.8995 1.49502e-06 0.8985 1.499e-06 0.8985 1.49902e-06 0.901 1.503e-06 0.901 1.50302e-06 0.899 1.507e-06 0.899 \
1.50702e-06 0.89975 1.511e-06 0.89975 1.51102e-06 0.9 1.515e-06 0.9 1.51502e-06 0.90025 1.519e-06 0.90025 1.51902e-06 0.9005 1.523e-06 0.9005 1.52302e-06 0.8995 1.527e-06 0.8995 1.52702e-06 0.899 1.531e-06 0.899 \
1.53102e-06 0.9015 1.535e-06 0.9015 1.53502e-06 0.9 1.539e-06 0.9 1.53902e-06 0.9005 1.543e-06 0.9005 1.54302e-06 0.89975 1.547e-06 0.89975 1.54702e-06 0.90025 1.551e-06 0.90025 1.55102e-06 0.8985 1.555e-06 0.8985 \
1.55502e-06 0.901 1.559e-06 0.901 1.55902e-06 0.899 1.563e-06 0.899 1.56302e-06 0.90025 1.567e-06 0.90025 1.56702e-06 0.9015 1.571e-06 0.9015 1.57102e-06 0.901 1.575e-06 0.901 1.57502e-06 0.8985 1.579e-06 0.8985 \
1.57902e-06 0.8995 1.583e-06 0.8995 1.58302e-06 0.9 1.587e-06 0.9 1.58702e-06 0.89975 1.591e-06 0.89975 1.59102e-06 0.9005 1.595e-06 0.9005 1.59502e-06 0.8995 1.599e-06 0.8995 1.59902e-06 0.9005 1.603e-06 0.9005 \
1.60302e-06 0.8985 1.607e-06 0.8985 1.60702e-06 0.9015 1.611e-06 0.9015 1.61102e-06 0.901 1.615e-06 0.901 1.61502e-06 0.90025 1.619e-06 0.90025 1.61902e-06 0.899 1.623e-06 0.899 1.62302e-06 0.89975 1.627e-06 0.89975 \
1.62702e-06 0.9 1.631e-06 0.9 1.63102e-06 0.8985 1.635e-06 0.8985 1.63502e-06 0.899 1.639e-06 0.899 1.63902e-06 0.9 1.643e-06 0.9 1.64302e-06 0.9005 1.647e-06 0.9005 1.64702e-06 0.901 1.651e-06 0.901 \
1.65102e-06 0.8995 1.655e-06 0.8995 1.65502e-06 0.89975 1.659e-06 0.89975 1.65902e-06 0.9015 1.663e-06 0.9015 1.66302e-06 0.90025 1.667e-06 0.90025 1.66702e-06 0.9 1.671e-06 0.9 1.67102e-06 0.89975 1.675e-06 0.89975 \
1.67502e-06 0.8985 1.679e-06 0.8985 1.67902e-06 0.8995 1.683e-06 0.8995 1.68302e-06 0.9005 1.687e-06 0.9005 1.68702e-06 0.9015 1.691e-06 0.9015 1.69102e-06 0.901 1.695e-06 0.901 1.69502e-06 0.899 1.699e-06 0.899 \
1.69902e-06 0.90025 1.703e-06 0.90025 1.70302e-06 0.9015 1.707e-06 0.9015 1.70702e-06 0.9005 1.711e-06 0.9005 1.71102e-06 0.8985 1.715e-06 0.8985 1.71502e-06 0.901 1.719e-06 0.901 1.71902e-06 0.89975 1.723e-06 0.89975 \
1.72302e-06 0.90025 1.727e-06 0.90025 1.72702e-06 0.8995 1.731e-06 0.8995 1.73102e-06 0.9 1.735e-06 0.9 1.73502e-06 0.899 1.739e-06 0.899 1.73902e-06 0.9005 1.743e-06 0.9005 1.74302e-06 0.8985 1.747e-06 0.8985 \
1.74702e-06 0.901 1.751e-06 0.901 1.75102e-06 0.90025 1.755e-06 0.90025 1.75502e-06 0.89975 1.759e-06 0.89975 1.75902e-06 0.9 1.763e-06 0.9 1.76302e-06 0.8995 1.767e-06 0.8995 1.76702e-06 0.899 1.771e-06 0.899 \
1.77102e-06 0.9015 1.775e-06 0.9015 1.77502e-06 0.90025 1.779e-06 0.90025 1.77902e-06 0.89975 1.783e-06 0.89975 1.78302e-06 0.9015 1.787e-06 0.9015 1.78702e-06 0.9 1.791e-06 0.9 1.79102e-06 0.8995 1.795e-06 0.8995 \
1.79502e-06 0.8985 1.799e-06 0.8985 1.79902e-06 0.899 1.803e-06 0.899 1.80302e-06 0.901 1.807e-06 0.901 1.80702e-06 0.9005 1.811e-06 0.9005 1.81102e-06 0.89975 1.815e-06 0.89975 1.81502e-06 0.9 1.819e-06 0.9 \
1.81902e-06 0.90025 1.823e-06 0.90025 1.82302e-06 0.899 1.827e-06 0.899 1.82702e-06 0.901 1.831e-06 0.901 1.83102e-06 0.8995 1.835e-06 0.8995 1.83502e-06 0.9005 1.839e-06 0.9005 1.83902e-06 0.8985 1.843e-06 0.8985 \
1.84302e-06 0.9015 1.847e-06 0.9015 1.84702e-06 0.8985 1.851e-06 0.8985 1.85102e-06 0.899 1.855e-06 0.899 1.85502e-06 0.90025 1.859e-06 0.90025 1.85902e-06 0.9005 1.863e-06 0.9005 1.86302e-06 0.89975 1.867e-06 0.89975 \
1.86702e-06 0.901 1.871e-06 0.901 1.87102e-06 0.9015 1.875e-06 0.9015 1.87502e-06 0.8995 1.879e-06 0.8995 1.87902e-06 0.9 1.883e-06 0.9 1.88302e-06 0.89975 1.887e-06 0.89975 1.88702e-06 0.8985 1.891e-06 0.8985 \
1.89102e-06 0.8995 1.895e-06 0.8995 1.89502e-06 0.9005 1.899e-06 0.9005 1.89902e-06 0.901 1.903e-06 0.901 1.90302e-06 0.9015 1.907e-06 0.9015 1.90702e-06 0.90025 1.911e-06 0.90025 1.91102e-06 0.899 1.915e-06 0.899 \
1.91502e-06 0.9 1.919e-06 0.9 1.91902e-06 0.9015 1.923e-06 0.9015 1.92302e-06 0.8985 1.927e-06 0.8985 1.92702e-06 0.90025 1.931e-06 0.90025 1.93102e-06 0.9 1.935e-06 0.9 1.93502e-06 0.899 1.939e-06 0.899 \
1.93902e-06 0.9005 1.943e-06 0.9005 1.94302e-06 0.89975 1.947e-06 0.89975 1.94702e-06 0.8995 1.951e-06 0.8995 1.95102e-06 0.901 1.955e-06 0.901 1.95502e-06 0.9 1.959e-06 0.9 1.95902e-06 0.9015 1.963e-06 0.9015 \
1.96302e-06 0.8985 1.967e-06 0.8985 1.96702e-06 0.8995 1.971e-06 0.8995 1.97102e-06 0.901 1.975e-06 0.901 1.97502e-06 0.899 1.979e-06 0.899 1.97902e-06 0.89975 1.983e-06 0.89975 1.98302e-06 0.9005 1.987e-06 0.9005 \
1.98702e-06 0.90025 1.991e-06 0.90025 1.99102e-06 0.9005 1.995e-06 0.9005 1.99502e-06 0.9 1.999e-06 0.9 1.99902e-06 0.8985 2.003e-06 0.8985 2.00302e-06 0.8995 2.007e-06 0.8995 2.00702e-06 0.901 2.011e-06 0.901 \
2.01102e-06 0.899 2.015e-06 0.899 2.01502e-06 0.9015 2.019e-06 0.9015 2.01902e-06 0.89975 2.023e-06 0.89975 2.02302e-06 0.90025 2.027e-06 0.90025 2.02702e-06 0.9005 2.031e-06 0.9005 2.03102e-06 0.90025 2.035e-06 0.90025 \
2.03502e-06 0.8985 2.039e-06 0.8985 2.03902e-06 0.9015 2.043e-06 0.9015 2.04302e-06 0.8995 2.047e-06 0.8995 2.04702e-06 0.89975 2.051e-06 0.89975 2.05102e-06 0.9 2.055e-06 0.9 2.05502e-06 0.901 2.059e-06 0.901 \
2.05902e-06 0.899 2.063e-06 0.899 2.06302e-06 0.901 2.067e-06 0.901 2.06702e-06 0.9 2.071e-06 0.9 2.07102e-06 0.89975 2.075e-06 0.89975 2.07502e-06 0.9015 2.079e-06 0.9015 2.07902e-06 0.90025 2.083e-06 0.90025 \
2.08302e-06 0.9005 2.087e-06 0.9005 2.08702e-06 0.8985 2.091e-06 0.8985 2.09102e-06 0.899 2.095e-06 0.899 2.09502e-06 0.8995 2.099e-06 0.8995 2.09902e-06 0.901 2.103e-06 0.901 2.10302e-06 0.8985 2.107e-06 0.8985 \
2.10702e-06 0.9 2.111e-06 0.9 2.11102e-06 0.9005 2.115e-06 0.9005 2.11502e-06 0.90025 2.119e-06 0.90025 2.11902e-06 0.9015 2.123e-06 0.9015 2.12302e-06 0.8995 2.127e-06 0.8995 2.12702e-06 0.899 2.131e-06 0.899 \
2.13102e-06 0.89975 2.135e-06 0.89975 2.13502e-06 0.8995 2.139e-06 0.8995 2.13902e-06 0.89975 2.143e-06 0.89975 2.14302e-06 0.899 2.147e-06 0.899 2.14702e-06 0.9015 2.151e-06 0.9015 2.15102e-06 0.90025 2.155e-06 0.90025 \
2.15502e-06 0.8985 2.159e-06 0.8985 2.15902e-06 0.901 2.163e-06 0.901 2.16302e-06 0.9005 2.167e-06 0.9005 2.16702e-06 0.9 2.171e-06 0.9 2.17102e-06 0.9005 2.175e-06 0.9005 2.17502e-06 0.89975 2.179e-06 0.89975 \
2.17902e-06 0.901 2.183e-06 0.901 2.18302e-06 0.8995 2.187e-06 0.8995 2.18702e-06 0.8985 2.191e-06 0.8985 2.19102e-06 0.90025 2.195e-06 0.90025 2.19502e-06 0.899 2.199e-06 0.899 2.19902e-06 0.9 2.203e-06 0.9 \
2.20302e-06 0.9015 2.207e-06 0.9015 2.20702e-06 0.899 2.211e-06 0.899 2.21102e-06 0.89975 2.215e-06 0.89975 2.21502e-06 0.901 2.219e-06 0.901 2.21902e-06 0.8995 2.223e-06 0.8995 2.22302e-06 0.8985 2.227e-06 0.8985 \
2.22702e-06 0.90025 2.231e-06 0.90025 2.23102e-06 0.9015 2.235e-06 0.9015 2.23502e-06 0.9 2.239e-06 0.9 2.23902e-06 0.9005 2.243e-06 0.9005 2.24302e-06 0.8995 2.247e-06 0.8995 2.24702e-06 0.8985 2.251e-06 0.8985 \
2.25102e-06 0.9005 2.255e-06 0.9005 2.25502e-06 0.899 2.259e-06 0.899 2.25902e-06 0.9015 2.263e-06 0.9015 2.26302e-06 0.89975 2.267e-06 0.89975 2.26702e-06 0.9 2.271e-06 0.9 2.27102e-06 0.90025 2.275e-06 0.90025 \
2.27502e-06 0.901 2.279e-06 0.901 2.27902e-06 0.901 2.283e-06 0.901 2.28302e-06 0.90025 2.287e-06 0.90025 2.28702e-06 0.8995 2.291e-06 0.8995 2.29102e-06 0.9005 2.295e-06 0.9005 2.29502e-06 0.8985 2.299e-06 0.8985 \
2.29902e-06 0.9 2.303e-06 0.9 2.30302e-06 0.899 2.307e-06 0.899 2.30702e-06 0.89975 2.311e-06 0.89975 2.31102e-06 0.9015 2.315e-06 0.9015 2.31502e-06 0.9015 2.319e-06 0.9015 2.31902e-06 0.90025 2.323e-06 0.90025 \
2.32302e-06 0.8985 2.327e-06 0.8985 2.32702e-06 0.9005 2.331e-06 0.9005 2.33102e-06 0.8995 2.335e-06 0.8995 2.33502e-06 0.899 2.339e-06 0.899 2.33902e-06 0.901 2.343e-06 0.901 2.34302e-06 0.89975 2.347e-06 0.89975 \
2.34702e-06 0.9 2.351e-06 0.9 2.35102e-06 0.8985 2.355e-06 0.8985 2.35502e-06 0.89975 2.359e-06 0.89975 2.35902e-06 0.9005 2.363e-06 0.9005 2.36302e-06 0.9 2.367e-06 0.9 2.36702e-06 0.9015 2.371e-06 0.9015 \
2.37102e-06 0.8995 2.375e-06 0.8995 2.37502e-06 0.899 2.379e-06 0.899 2.37902e-06 0.90025 2.383e-06 0.90025 2.38302e-06 0.901 2.387e-06 0.901 2.38702e-06 0.8995 2.391e-06 0.8995 2.39102e-06 0.899 2.395e-06 0.899 \
2.39502e-06 0.90025 2.399e-06 0.90025 2.39902e-06 0.8985 2.403e-06 0.8985 2.40302e-06 0.9 2.407e-06 0.9 2.40702e-06 0.9015 2.411e-06 0.9015 2.41102e-06 0.901 2.415e-06 0.901 2.41502e-06 0.89975 2.419e-06 0.89975 \
2.41902e-06 0.9005 2.423e-06 0.9005 2.42302e-06 0.8995 2.427e-06 0.8995 2.42702e-06 0.899 2.431e-06 0.899 2.43102e-06 0.8985 2.435e-06 0.8985 2.43502e-06 0.901 2.439e-06 0.901 2.43902e-06 0.89975 2.443e-06 0.89975 \
2.44302e-06 0.9005 2.447e-06 0.9005 2.44702e-06 0.9 2.451e-06 0.9 2.45102e-06 0.90025 2.455e-06 0.90025 2.45502e-06 0.9015 2.459e-06 0.9015 2.45902e-06 0.89975 2.463e-06 0.89975 2.46302e-06 0.8995 2.467e-06 0.8995 \
2.46702e-06 0.90025 2.471e-06 0.90025 2.47102e-06 0.9005 2.475e-06 0.9005 2.47502e-06 0.9 2.479e-06 0.9 2.47902e-06 0.899 2.483e-06 0.899 2.48302e-06 0.9015 2.487e-06 0.9015 2.48702e-06 0.8985 2.491e-06 0.8985 \
2.49102e-06 0.901 2.495e-06 0.901 2.49502e-06 0.8995 2.499e-06 0.8995 2.49902e-06 0.9015 2.503e-06 0.9015 2.50302e-06 0.90025 2.507e-06 0.90025 2.50702e-06 0.901 2.511e-06 0.901 2.51102e-06 0.899 2.515e-06 0.899 \
2.51502e-06 0.89975 2.519e-06 0.89975 2.51902e-06 0.8985 2.523e-06 0.8985 2.52302e-06 0.9 2.527e-06 0.9 2.52702e-06 0.9005 2.531e-06 0.9005 2.53102e-06 0.8985 2.535e-06 0.8985 2.53502e-06 0.9015 2.539e-06 0.9015 \
2.53902e-06 0.901 2.543e-06 0.901 2.54302e-06 0.9 2.547e-06 0.9 2.54702e-06 0.899 2.551e-06 0.899 2.55102e-06 0.89975 2.555e-06 0.89975 2.55502e-06 0.90025 2.559e-06 0.90025 2.55902e-06 0.8995 2.563e-06 0.8995 \
2.56302e-06 0.9005 2.567e-06 0.9005 2.56702e-06 0.89975 2.571e-06 0.89975 2.57102e-06 0.9015 2.575e-06 0.9015 2.57502e-06 0.899 2.579e-06 0.899 2.57902e-06 0.9 2.583e-06 0.9 2.58302e-06 0.901 2.587e-06 0.901 \
2.58702e-06 0.9005 2.591e-06 0.9005 2.59102e-06 0.8995 2.595e-06 0.8995 2.59502e-06 0.8985 2.599e-06 0.8985 2.59902e-06 0.90025 2.603e-06 0.90025 2.60302e-06 0.8995 2.607e-06 0.8995 2.60702e-06 0.899 2.611e-06 0.899 \
2.61102e-06 0.9005 2.615e-06 0.9005 2.61502e-06 0.89975 2.619e-06 0.89975 2.61902e-06 0.9015 2.623e-06 0.9015 2.62302e-06 0.9 2.627e-06 0.9 2.62702e-06 0.90025 2.631e-06 0.90025 2.63102e-06 0.901 2.635e-06 0.901 \
2.63502e-06 0.8985 2.639e-06 0.8985 2.63902e-06 0.89975 2.643e-06 0.89975 2.64302e-06 0.901 2.647e-06 0.901 2.64702e-06 0.90025 2.651e-06 0.90025 2.65102e-06 0.8995 2.655e-06 0.8995 2.65502e-06 0.8985 2.659e-06 0.8985 \
2.65902e-06 0.899 2.663e-06 0.899 2.66302e-06 0.9015 2.667e-06 0.9015 2.66702e-06 0.9 2.671e-06 0.9 2.67102e-06 0.9005 2.675e-06 0.9005 2.67502e-06 0.9005 2.679e-06 0.9005 2.67902e-06 0.9015 2.683e-06 0.9015 \
2.68302e-06 0.89975 2.687e-06 0.89975 2.68702e-06 0.901 2.691e-06 0.901 2.69102e-06 0.8985 2.695e-06 0.8985 2.69502e-06 0.899 2.699e-06 0.899 2.69902e-06 0.8995 2.703e-06 0.8995 2.70302e-06 0.90025 2.707e-06 0.90025 \
2.70702e-06 0.9 2.711e-06 0.9 2.71102e-06 0.9 2.715e-06 0.9 2.71502e-06 0.9015 2.719e-06 0.9015 2.71902e-06 0.90025 2.723e-06 0.90025 2.72302e-06 0.9005 2.727e-06 0.9005 2.72702e-06 0.8995 2.731e-06 0.8995 \
2.73102e-06 0.8985 2.735e-06 0.8985 2.73502e-06 0.901 2.739e-06 0.901 2.73902e-06 0.89975 2.743e-06 0.89975 2.74302e-06 0.899 2.747e-06 0.899 2.74702e-06 0.9015 2.751e-06 0.9015 2.75102e-06 0.8995 2.755e-06 0.8995 \
2.75502e-06 0.90025 2.759e-06 0.90025 2.75902e-06 0.901 2.763e-06 0.901 2.76302e-06 0.89975 2.767e-06 0.89975 2.76702e-06 0.9 2.771e-06 0.9 2.77102e-06 0.9005 2.775e-06 0.9005 2.77502e-06 0.8985 2.779e-06 0.8985 \
2.77902e-06 0.899 2.783e-06 0.899 2.78302e-06 0.899 2.787e-06 0.899 2.78702e-06 0.9005 2.791e-06 0.9005 2.79102e-06 0.9 2.795e-06 0.9 2.79502e-06 0.90025 2.799e-06 0.90025 2.79902e-06 0.9015 2.803e-06 0.9015 \
2.80302e-06 0.8985 2.807e-06 0.8985 2.80702e-06 0.901 2.811e-06 0.901 2.81102e-06 0.8995 2.815e-06 0.8995 2.81502e-06 0.89975 2.819e-06 0.89975 2.81902e-06 0.90025 2.823e-06 0.90025 2.82302e-06 0.9015 2.827e-06 0.9015 \
2.82702e-06 0.8985 2.831e-06 0.8985 2.83102e-06 0.9 2.835e-06 0.9 2.83502e-06 0.9005 2.839e-06 0.9005 2.83902e-06 0.89975 2.843e-06 0.89975 2.84302e-06 0.901 2.847e-06 0.901 2.84702e-06 0.8995 2.851e-06 0.8995 \
2.85102e-06 0.899 2.855e-06 0.899 2.85502e-06 0.9015 2.859e-06 0.9015 2.85902e-06 0.90025 2.863e-06 0.90025 2.86302e-06 0.901 2.867e-06 0.901 2.86702e-06 0.899 2.871e-06 0.899 2.87102e-06 0.9005 2.875e-06 0.9005 \
2.87502e-06 0.9 2.879e-06 0.9 2.87902e-06 0.89975 2.883e-06 0.89975 2.88302e-06 0.8995 2.887e-06 0.8995 2.88702e-06 0.8985 2.891e-06 0.8985 2.89102e-06 0.899 2.895e-06 0.899 2.89502e-06 0.90025 2.899e-06 0.90025 \
2.89902e-06 0.9015 2.903e-06 0.9015 2.90302e-06 0.8995 2.907e-06 0.8995 2.90702e-06 0.9 2.911e-06 0.9 2.91102e-06 0.901 2.915e-06 0.901 2.91502e-06 0.9005 2.919e-06 0.9005 2.91902e-06 0.8985 2.923e-06 0.8985 \
2.92302e-06 0.89975 2.927e-06 0.89975 2.92702e-06 0.90025 2.931e-06 0.90025 2.93102e-06 0.9 2.935e-06 0.9 2.93502e-06 0.901 2.939e-06 0.901 2.93902e-06 0.9005 2.943e-06 0.9005 2.94302e-06 0.899 2.947e-06 0.899 \
2.94702e-06 0.9015 2.951e-06 0.9015 2.95102e-06 0.8985 2.955e-06 0.8985 2.95502e-06 0.8995 2.959e-06 0.8995 2.95902e-06 0.89975 2.963e-06 0.89975 2.96302e-06 0.8985 2.967e-06 0.8985 2.96702e-06 0.901 2.971e-06 0.901 \
2.97102e-06 0.9 2.975e-06 0.9 2.97502e-06 0.9015 2.979e-06 0.9015 2.97902e-06 0.89975 2.983e-06 0.89975 2.98302e-06 0.8995 2.987e-06 0.8995 2.98702e-06 0.9005 2.991e-06 0.9005 2.99102e-06 0.899 2.995e-06 0.899 \
2.99502e-06 0.90025 2.999e-06 0.90025 2.99902e-06 0.899 3.003e-06 0.899 3.00302e-06 0.901 3.007e-06 0.901 3.00702e-06 0.90025 3.011e-06 0.90025 3.01102e-06 0.89975 3.015e-06 0.89975 3.01502e-06 0.8985 3.019e-06 0.8985 \
3.01902e-06 0.8995 3.023e-06 0.8995 3.02302e-06 0.9 3.027e-06 0.9 3.02702e-06 0.9005 3.031e-06 0.9005 3.03102e-06 0.9015 3.035e-06 0.9015 3.03502e-06 0.9015 3.039e-06 0.9015 3.03902e-06 0.89975 3.043e-06 0.89975 \
3.04302e-06 0.9 3.047e-06 0.9 3.04702e-06 0.9005 3.051e-06 0.9005 3.05102e-06 0.901 3.055e-06 0.901 3.05502e-06 0.899 3.059e-06 0.899 3.05902e-06 0.8985 3.063e-06 0.8985 3.06302e-06 0.90025 3.067e-06 0.90025 \
3.06702e-06 0.8995 3.071e-06 0.8995 3.07102e-06 0.9015 3.075e-06 0.9015 3.07502e-06 0.901 3.079e-06 0.901 3.07902e-06 0.8985 3.083e-06 0.8985 3.08302e-06 0.8995 3.087e-06 0.8995 3.08702e-06 0.899 3.091e-06 0.899 \
3.09102e-06 0.9 3.095e-06 0.9 3.09502e-06 0.9005 3.099e-06 0.9005 3.09902e-06 0.90025 3.103e-06 0.90025 3.10302e-06 0.89975 3.107e-06 0.89975 3.10702e-06 0.901 3.111e-06 0.901 3.11102e-06 0.899 3.115e-06 0.899 \
3.11502e-06 0.8985 3.119e-06 0.8985 3.11902e-06 0.90025 3.123e-06 0.90025 3.12302e-06 0.9015 3.127e-06 0.9015 3.12702e-06 0.8995 3.131e-06 0.8995 3.13102e-06 0.89975 3.135e-06 0.89975 3.13502e-06 0.9005 3.139e-06 0.9005 \
3.13902e-06 0.9 3.143e-06 0.9 3.14302e-06 0.8985 3.147e-06 0.8985 3.14702e-06 0.901 3.151e-06 0.901 3.15102e-06 0.9 3.155e-06 0.9 3.15502e-06 0.8995 3.159e-06 0.8995 3.15902e-06 0.9015 3.163e-06 0.9015 \
3.16302e-06 0.9005 3.167e-06 0.9005 3.16702e-06 0.90025 3.171e-06 0.90025 3.17102e-06 0.899 3.175e-06 0.899 3.17502e-06 0.89975 3.179e-06 0.89975 3.17902e-06 0.9 3.183e-06 0.9 3.18302e-06 0.8985 3.187e-06 0.8985 \
3.18702e-06 0.901 3.191e-06 0.901 3.19102e-06 0.89975 3.195e-06 0.89975 3.19502e-06 0.899 3.199e-06 0.899 3.19902e-06 0.90025 3.203e-06 0.90025 3.20302e-06 0.9005 3.207e-06 0.9005 3.20702e-06 0.8995 3.211e-06 0.8995 \
3.21102e-06 0.9015 3.215e-06 0.9015 3.21502e-06 0.9015 3.219e-06 0.9015 3.21902e-06 0.899 3.223e-06 0.899 3.22302e-06 0.89975 3.227e-06 0.89975 3.22702e-06 0.90025 3.231e-06 0.90025 3.23102e-06 0.901 3.235e-06 0.901 \
3.23502e-06 0.8995 3.239e-06 0.8995 3.23902e-06 0.9005 3.243e-06 0.9005 3.24302e-06 0.9 3.247e-06 0.9 3.24702e-06 0.8985 3.251e-06 0.8985 3.25102e-06 0.899 3.255e-06 0.899 3.25502e-06 0.901 3.259e-06 0.901 \
3.25902e-06 0.8995 3.263e-06 0.8995 3.26302e-06 0.8985 3.267e-06 0.8985 3.26702e-06 0.9005 3.271e-06 0.9005 3.27102e-06 0.89975 3.275e-06 0.89975 3.27502e-06 0.9015 3.279e-06 0.9015 3.27902e-06 0.90025 3.283e-06 0.90025 \
3.28302e-06 0.9 3.287e-06 0.9 3.28702e-06 0.9005 3.291e-06 0.9005 3.29102e-06 0.89975 3.295e-06 0.89975 3.29502e-06 0.899 3.299e-06 0.899 3.29902e-06 0.9015 3.303e-06 0.9015 3.30302e-06 0.8995 3.307e-06 0.8995 \
3.30702e-06 0.9 3.311e-06 0.9 3.31102e-06 0.8985 3.315e-06 0.8985 3.31502e-06 0.90025 3.319e-06 0.90025 3.31902e-06 0.901 3.323e-06 0.901 3.32302e-06 0.89975 3.327e-06 0.89975 3.32702e-06 0.899 3.331e-06 0.899 \
3.33102e-06 0.8995 3.335e-06 0.8995 3.33502e-06 0.9 3.339e-06 0.9 3.33902e-06 0.901 3.343e-06 0.901 3.34302e-06 0.90025 3.347e-06 0.90025 3.34702e-06 0.9015 3.351e-06 0.9015 3.35102e-06 0.9005 3.355e-06 0.9005 \
3.35502e-06 0.8985 3.359e-06 0.8985 3.35902e-06 0.8985 3.363e-06 0.8985 3.36302e-06 0.899 3.367e-06 0.899 3.36702e-06 0.8995 3.371e-06 0.8995 3.37102e-06 0.9 3.375e-06 0.9 3.37502e-06 0.901 3.379e-06 0.901 \
3.37902e-06 0.90025 3.383e-06 0.90025 3.38302e-06 0.9015 3.387e-06 0.9015 3.38702e-06 0.9005 3.391e-06 0.9005 3.39102e-06 0.89975 3.395e-06 0.89975 3.39502e-06 0.89975 3.399e-06 0.89975 3.39902e-06 0.9005 3.403e-06 0.9005 \
3.40302e-06 0.9015 3.407e-06 0.9015 3.40702e-06 0.901 3.411e-06 0.901 3.41102e-06 0.8985 3.415e-06 0.8985 3.41502e-06 0.90025 3.419e-06 0.90025 3.41902e-06 0.9 3.423e-06 0.9 3.42302e-06 0.899 3.427e-06 0.899 \
3.42702e-06 0.8995 3.431e-06 0.8995 3.43102e-06 0.901 3.435e-06 0.901 3.43502e-06 0.899 3.439e-06 0.899 3.43902e-06 0.8995 3.443e-06 0.8995 3.44302e-06 0.90025 3.447e-06 0.90025 3.44702e-06 0.9 3.451e-06 0.9 \
3.45102e-06 0.9015 3.455e-06 0.9015 3.45502e-06 0.8985 3.459e-06 0.8985 3.45902e-06 0.9005 3.463e-06 0.9005 3.46302e-06 0.89975 3.467e-06 0.89975 3.46702e-06 0.9005 3.471e-06 0.9005 3.47102e-06 0.901 3.475e-06 0.901 \
3.47502e-06 0.89975 3.479e-06 0.89975 3.47902e-06 0.899 3.483e-06 0.899 3.48302e-06 0.9 3.487e-06 0.9 3.48702e-06 0.8985 3.491e-06 0.8985 3.49102e-06 0.90025 3.495e-06 0.90025 3.49502e-06 0.8995 3.499e-06 0.8995 \
3.49902e-06 0.9015 3.503e-06 0.9015 3.50302e-06 0.9015 3.507e-06 0.9015 3.50702e-06 0.89975 3.511e-06 0.89975 3.51102e-06 0.901 3.515e-06 0.901 3.51502e-06 0.899 3.519e-06 0.899 3.51902e-06 0.90025 3.523e-06 0.90025 \
3.52302e-06 0.8995 3.527e-06 0.8995 3.52702e-06 0.9 3.531e-06 0.9 3.53102e-06 0.8985 3.535e-06 0.8985 3.53502e-06 0.9005 3.539e-06 0.9005 3.53902e-06 0.8985 3.543e-06 0.8985 3.54302e-06 0.9005 3.547e-06 0.9005 \
3.54702e-06 0.8995 3.551e-06 0.8995 3.55102e-06 0.9015 3.555e-06 0.9015 3.55502e-06 0.901 3.559e-06 0.901 3.55902e-06 0.9 3.563e-06 0.9 3.56302e-06 0.89975 3.567e-06 0.89975 3.56702e-06 0.90025 3.571e-06 0.90025 \
3.57102e-06 0.899 3.575e-06 0.899 3.57502e-06 0.8995 3.579e-06 0.8995 3.57902e-06 0.9005 3.583e-06 0.9005 3.58302e-06 0.901 3.587e-06 0.901 3.58702e-06 0.899 3.591e-06 0.899 3.59102e-06 0.9015 3.595e-06 0.9015 \
3.59502e-06 0.8985 3.599e-06 0.8985 3.59902e-06 0.90025 3.603e-06 0.90025 3.60302e-06 0.9 3.607e-06 0.9 3.60702e-06 0.89975 3.611e-06 0.89975 3.61102e-06 0.8995 3.615e-06 0.8995 3.61502e-06 0.9005 3.619e-06 0.9005 \
3.61902e-06 0.901 3.623e-06 0.901 3.62302e-06 0.90025 3.627e-06 0.90025 3.62702e-06 0.8985 3.631e-06 0.8985 3.63102e-06 0.89975 3.635e-06 0.89975 3.63502e-06 0.899 3.639e-06 0.899 3.63902e-06 0.9 3.643e-06 0.9 \
3.64302e-06 0.9015 3.647e-06 0.9015 3.64702e-06 0.901 3.651e-06 0.901 3.65102e-06 0.9 3.655e-06 0.9 3.65502e-06 0.8985 3.659e-06 0.8985 3.65902e-06 0.89975 3.663e-06 0.89975 3.66302e-06 0.9005 3.667e-06 0.9005 \
3.66702e-06 0.899 3.671e-06 0.899 3.67102e-06 0.8995 3.675e-06 0.8995 3.67502e-06 0.90025 3.679e-06 0.90025 3.67902e-06 0.9015 3.683e-06 0.9015 3.68302e-06 0.8995 3.687e-06 0.8995 3.68702e-06 0.9015 3.691e-06 0.9015 \
3.69102e-06 0.9 3.695e-06 0.9 3.69502e-06 0.901 3.699e-06 0.901 3.69902e-06 0.89975 3.703e-06 0.89975 3.70302e-06 0.899 3.707e-06 0.899 3.70702e-06 0.9005 3.711e-06 0.9005 3.71102e-06 0.8985 3.715e-06 0.8985 \
3.71502e-06 0.90025 3.719e-06 0.90025 3.71902e-06 0.89975 3.723e-06 0.89975 3.72302e-06 0.9015 3.727e-06 0.9015 3.72702e-06 0.899 3.731e-06 0.899 3.73102e-06 0.9 3.735e-06 0.9 3.73502e-06 0.8995 3.739e-06 0.8995 \
3.73902e-06 0.90025 3.743e-06 0.90025 3.74302e-06 0.9005 3.747e-06 0.9005 3.74702e-06 0.8985 3.751e-06 0.8985 3.75102e-06 0.901 3.755e-06 0.901 3.75502e-06 0.89975 3.759e-06 0.89975 3.75902e-06 0.8995 3.763e-06 0.8995 \
3.76302e-06 0.9 3.767e-06 0.9 3.76702e-06 0.8985 3.771e-06 0.8985 3.77102e-06 0.9005 3.775e-06 0.9005 3.77502e-06 0.9015 3.779e-06 0.9015 3.77902e-06 0.901 3.783e-06 0.901 3.78302e-06 0.899 3.787e-06 0.899 \
3.78702e-06 0.90025 3.791e-06 0.90025 3.79102e-06 0.9015 3.795e-06 0.9015 3.79502e-06 0.8985 3.799e-06 0.8985 3.79902e-06 0.899 3.803e-06 0.899 3.80302e-06 0.901 3.807e-06 0.901 3.80702e-06 0.8995 3.811e-06 0.8995 \
3.81102e-06 0.90025 3.815e-06 0.90025 3.81502e-06 0.9005 3.819e-06 0.9005 3.81902e-06 0.9 3.823e-06 0.9 3.82302e-06 0.89975 3.827e-06 0.89975 3.82702e-06 0.90025 3.831e-06 0.90025 3.83102e-06 0.9015 3.835e-06 0.9015 \
3.83502e-06 0.8985 3.839e-06 0.8985 3.83902e-06 0.89975 3.843e-06 0.89975 3.84302e-06 0.9005 3.847e-06 0.9005 3.84702e-06 0.899 3.851e-06 0.899 3.85102e-06 0.8995 3.855e-06 0.8995 3.85502e-06 0.901 3.859e-06 0.901 \
3.85902e-06 0.9 3.863e-06 0.9 3.86302e-06 0.8985 3.867e-06 0.8985 3.86702e-06 0.899 3.871e-06 0.899 3.87102e-06 0.89975 3.875e-06 0.89975 3.87502e-06 0.8995 3.879e-06 0.8995 3.87902e-06 0.9015 3.883e-06 0.9015 \
3.88302e-06 0.901 3.887e-06 0.901 3.88702e-06 0.9005 3.891e-06 0.9005 3.89102e-06 0.9 3.895e-06 0.9 3.89502e-06 0.90025 3.899e-06 0.90025 3.89902e-06 0.899 3.903e-06 0.899 3.90302e-06 0.89975 3.907e-06 0.89975 \
3.90702e-06 0.90025 3.911e-06 0.90025 3.91102e-06 0.9005 3.915e-06 0.9005 3.91502e-06 0.8995 3.919e-06 0.8995 3.91902e-06 0.8985 3.923e-06 0.8985 3.92302e-06 0.901 3.927e-06 0.901 3.92702e-06 0.9 3.931e-06 0.9 \
3.93102e-06 0.9015 3.935e-06 0.9015 3.93502e-06 0.9005 3.939e-06 0.9005 3.93902e-06 0.90025 3.943e-06 0.90025 3.94302e-06 0.899 3.947e-06 0.899 3.94702e-06 0.8985 3.951e-06 0.8985 3.95102e-06 0.901 3.955e-06 0.901 \
3.95502e-06 0.9 3.959e-06 0.9 3.95902e-06 0.9015 3.963e-06 0.9015 3.96302e-06 0.89975 3.967e-06 0.89975 3.96702e-06 0.8995 3.971e-06 0.8995 3.97102e-06 0.9 3.975e-06 0.9 3.97502e-06 0.9015 3.979e-06 0.9015 \
3.97902e-06 0.90025 3.983e-06 0.90025 3.98302e-06 0.9005 3.987e-06 0.9005 3.98702e-06 0.901 3.991e-06 0.901 3.99102e-06 0.8995 3.995e-06 0.8995 3.99502e-06 0.8985 3.999e-06 0.8985 3.99902e-06 0.89975 4.003e-06 0.89975 \
4.00302e-06 0.899 4.007e-06 0.899 4.00702e-06 0.8985 4.011e-06 0.8985 4.01102e-06 0.90025 4.015e-06 0.90025 4.01502e-06 0.899 4.019e-06 0.899 4.01902e-06 0.901 4.023e-06 0.901 4.02302e-06 0.9 4.027e-06 0.9 \
4.02702e-06 0.9015 4.031e-06 0.9015 4.03102e-06 0.89975 4.035e-06 0.89975 4.03502e-06 0.8995 4.039e-06 0.8995 4.03902e-06 0.9005 4.043e-06 0.9005 4.04302e-06 0.89975 4.047e-06 0.89975 4.04702e-06 0.9 4.051e-06 0.9 \
4.05102e-06 0.8985 4.055e-06 0.8985 4.05502e-06 0.9015 4.059e-06 0.9015 4.05902e-06 0.901 4.063e-06 0.901 4.06302e-06 0.899 4.067e-06 0.899 4.06702e-06 0.9005 4.071e-06 0.9005 4.07102e-06 0.8995 4.075e-06 0.8995 \
4.07502e-06 0.90025 4.079e-06 0.90025 4.07902e-06 0.899 4.083e-06 0.899 4.08302e-06 0.9015 4.087e-06 0.9015 4.08702e-06 0.90025 4.091e-06 0.90025 4.09102e-06 0.8995 4.095e-06 0.8995 4.09502e-06 0.9005 4.099e-06 0.9005 \
4.09902e-06 0.9 4.103e-06 0.9 4.10302e-06 0.89975 4.107e-06 0.89975 4.10702e-06 0.8985 4.111e-06 0.8985 4.11102e-06 0.901 4.115e-06 0.901 4.11502e-06 0.9 4.119e-06 0.9 4.11902e-06 0.899 4.123e-06 0.899 \
4.12302e-06 0.9015 4.127e-06 0.9015 4.12702e-06 0.8995 4.131e-06 0.8995 4.13102e-06 0.901 4.135e-06 0.901 4.13502e-06 0.9005 4.139e-06 0.9005 4.13902e-06 0.89975 4.143e-06 0.89975 4.14302e-06 0.8985 4.147e-06 0.8985 \
4.14702e-06 0.90025 4.151e-06 0.90025 4.15102e-06 0.9015 4.155e-06 0.9015 4.15502e-06 0.90025 4.159e-06 0.90025 4.15902e-06 0.8985 4.163e-06 0.8985 4.16302e-06 0.89975 4.167e-06 0.89975 4.16702e-06 0.8995 4.171e-06 0.8995 \
4.17102e-06 0.9005 4.175e-06 0.9005 4.17502e-06 0.899 4.179e-06 0.899 4.17902e-06 0.9 4.183e-06 0.9 4.18302e-06 0.901 4.187e-06 0.901 4.18702e-06 0.899 4.191e-06 0.899 4.19102e-06 0.901 4.195e-06 0.901 \
4.19502e-06 0.89975 4.199e-06 0.89975 4.19902e-06 0.8995 4.203e-06 0.8995 4.20302e-06 0.9 4.207e-06 0.9 4.20702e-06 0.9015 4.211e-06 0.9015 4.21102e-06 0.90025 4.215e-06 0.90025 4.21502e-06 0.9005 4.219e-06 0.9005 \
4.21902e-06 0.8985 4.223e-06 0.8985 4.22302e-06 0.9015 4.227e-06 0.9015 4.22702e-06 0.8985 4.231e-06 0.8985 4.23102e-06 0.9 4.235e-06 0.9 4.23502e-06 0.90025 4.239e-06 0.90025 4.23902e-06 0.9005 4.243e-06 0.9005 \
4.24302e-06 0.899 4.247e-06 0.899 4.24702e-06 0.901 4.251e-06 0.901 4.25102e-06 0.89975 4.255e-06 0.89975 4.25502e-06 0.8995 4.259e-06 0.8995 4.25902e-06 0.90025 4.263e-06 0.90025 4.26302e-06 0.8995 4.267e-06 0.8995 \
4.26702e-06 0.9005 4.271e-06 0.9005 4.27102e-06 0.899 4.275e-06 0.899 4.27502e-06 0.9 4.279e-06 0.9 4.27902e-06 0.9015 4.283e-06 0.9015 4.28302e-06 0.901 4.287e-06 0.901 4.28702e-06 0.8985 4.291e-06 0.8985 \
4.29102e-06 0.89975 4.295e-06 0.89975 4.29502e-06 0.8985 4.299e-06 0.8985 4.29902e-06 0.9 4.303e-06 0.9 4.30302e-06 0.90025 4.307e-06 0.90025 4.30702e-06 0.8995 4.311e-06 0.8995 4.31102e-06 0.9015 4.315e-06 0.9015 \
4.31502e-06 0.89975 4.319e-06 0.89975 4.31902e-06 0.899 4.323e-06 0.899 4.32302e-06 0.901 4.327e-06 0.901 4.32702e-06 0.9005 4.331e-06 0.9005 4.33102e-06 0.90025 4.335e-06 0.90025 4.33502e-06 0.901 4.339e-06 0.901 \
4.33902e-06 0.9005 4.343e-06 0.9005 4.34302e-06 0.89975 4.347e-06 0.89975 4.34702e-06 0.9015 4.351e-06 0.9015 4.35102e-06 0.899 4.355e-06 0.899 4.35502e-06 0.8995 4.359e-06 0.8995 4.35902e-06 0.9 4.363e-06 0.9 \
4.36302e-06 0.8985 4.367e-06 0.8985 4.36702e-06 0.8985 4.371e-06 0.8985 4.37102e-06 0.8995 4.375e-06 0.8995 4.37502e-06 0.899 4.379e-06 0.899 4.37902e-06 0.89975 4.383e-06 0.89975 4.38302e-06 0.9 4.387e-06 0.9 \
4.38702e-06 0.90025 4.391e-06 0.90025 4.39102e-06 0.9005 4.395e-06 0.9005 4.39502e-06 0.901 4.399e-06 0.901 4.39902e-06 0.9015 4.403e-06 0.9015 4.40302e-06 0.90025 4.407e-06 0.90025 4.40702e-06 0.9005 4.411e-06 0.9005 \
4.41102e-06 0.89975 4.415e-06 0.89975 4.41502e-06 0.9015 4.419e-06 0.9015 4.41902e-06 0.899 4.423e-06 0.899 4.42302e-06 0.9 4.427e-06 0.9 4.42702e-06 0.8985 4.431e-06 0.8985 4.43102e-06 0.8995 4.435e-06 0.8995 \
4.43502e-06 0.901 4.439e-06 0.901 4.43902e-06 0.8995 4.443e-06 0.8995 4.44302e-06 0.90025 4.447e-06 0.90025 4.44702e-06 0.901 4.451e-06 0.901 4.45102e-06 0.9 4.455e-06 0.9 4.45502e-06 0.899 4.459e-06 0.899 \
4.45902e-06 0.9015 4.463e-06 0.9015 4.46302e-06 0.89975 4.467e-06 0.89975 4.46702e-06 0.9005 4.471e-06 0.9005 4.47102e-06 0.8985 4.475e-06 0.8985 4.47502e-06 0.9 4.479e-06 0.9 4.47902e-06 0.899 4.483e-06 0.899 \
4.48302e-06 0.901 4.487e-06 0.901 4.48702e-06 0.90025 4.491e-06 0.90025 4.49102e-06 0.9005 4.495e-06 0.9005 4.49502e-06 0.8985 4.499e-06 0.8985 4.49902e-06 0.9015 4.503e-06 0.9015 4.50302e-06 0.8995 4.507e-06 0.8995 \
4.50702e-06 0.89975 4.511e-06 0.89975 4.51102e-06 0.9005 4.515e-06 0.9005 4.51502e-06 0.901 4.519e-06 0.901 4.51902e-06 0.90025 4.523e-06 0.90025 4.52302e-06 0.89975 4.527e-06 0.89975 4.52702e-06 0.8985 4.531e-06 0.8985 \
4.53102e-06 0.9 4.535e-06 0.9 4.53502e-06 0.8995 4.539e-06 0.8995 4.53902e-06 0.9015 4.543e-06 0.9015 4.54302e-06 0.899 4.547e-06 0.899 4.54702e-06 0.9015 4.551e-06 0.9015 4.55102e-06 0.9 4.555e-06 0.9 \
4.55502e-06 0.8995 4.559e-06 0.8995 4.55902e-06 0.899 4.563e-06 0.899 4.56302e-06 0.901 4.567e-06 0.901 4.56702e-06 0.90025 4.571e-06 0.90025 4.57102e-06 0.9005 4.575e-06 0.9005 4.57502e-06 0.89975 4.579e-06 0.89975 \
4.57902e-06 0.8985 4.583e-06 0.8985 4.58302e-06 0.8995 4.587e-06 0.8995 4.58702e-06 0.899 4.591e-06 0.899 4.59102e-06 0.89975 4.595e-06 0.89975 4.59502e-06 0.901 4.599e-06 0.901 4.59902e-06 0.8985 4.603e-06 0.8985 \
4.60302e-06 0.9015 4.607e-06 0.9015 4.60702e-06 0.90025 4.611e-06 0.90025 4.61102e-06 0.9005 4.615e-06 0.9005 4.61502e-06 0.9 4.619e-06 0.9 4.61902e-06 0.901 4.623e-06 0.901 4.62302e-06 0.899 4.627e-06 0.899 \
4.62702e-06 0.9 4.631e-06 0.9 4.63102e-06 0.89975 4.635e-06 0.89975 4.63502e-06 0.8985 4.639e-06 0.8985 4.63902e-06 0.9005 4.643e-06 0.9005 4.64302e-06 0.8995 4.647e-06 0.8995 4.64702e-06 0.90025 4.651e-06 0.90025 \
4.65102e-06 0.9015 4.655e-06 0.9015 4.65502e-06 0.9015 4.659e-06 0.9015 4.65902e-06 0.899 4.663e-06 0.899 4.66302e-06 0.89975 4.667e-06 0.89975 4.66702e-06 0.901 4.671e-06 0.901 4.67102e-06 0.9 4.675e-06 0.9 \
4.67502e-06 0.90025 4.679e-06 0.90025 4.67902e-06 0.9005 4.683e-06 0.9005 4.68302e-06 0.8995 4.687e-06 0.8995 4.68702e-06 0.8985 4.691e-06 0.8985 4.69102e-06 0.9 4.695e-06 0.9 4.69502e-06 0.901 4.699e-06 0.901 \
4.69902e-06 0.899 4.703e-06 0.899 4.70302e-06 0.90025 4.707e-06 0.90025 4.70702e-06 0.89975 4.711e-06 0.89975 4.71102e-06 0.8995 4.715e-06 0.8995 4.71502e-06 0.9005 4.719e-06 0.9005 4.71902e-06 0.9015 4.723e-06 0.9015 \
4.72302e-06 0.8985 4.727e-06 0.8985 4.72702e-06 0.1115 4.731e-06 0.1115 4.73102e-06 0.1135 4.735e-06 0.1135 4.73502e-06 0.113 4.739e-06 0.113 4.73902e-06 0.11225 4.743e-06 0.11225 4.74302e-06 0.111 4.747e-06 0.111 \
4.74702e-06 0.1125 4.751e-06 0.1125 4.75102e-06 0.112 4.755e-06 0.112 4.75502e-06 0.114 4.759e-06 0.114 4.75902e-06 0.11275 4.763e-06 0.11275 4.76302e-06 0.1115 4.767e-06 0.1115 4.76702e-06 0.112 4.771e-06 0.112 \
4.77102e-06 0.111 4.775e-06 0.111 4.77502e-06 0.114 4.779e-06 0.114 4.77902e-06 0.11275 4.783e-06 0.11275 4.78302e-06 0.11225 4.787e-06 0.11225 4.78702e-06 0.1135 4.791e-06 0.1135 4.79102e-06 0.113 4.795e-06 0.113 \
4.79502e-06 0.1125 4.799e-06 0.1125 4.79902e-06 0.112 4.803e-06 0.112 4.80302e-06 0.111 4.807e-06 0.111 4.80702e-06 0.11275 4.811e-06 0.11275 4.81102e-06 0.114 4.815e-06 0.114 4.81502e-06 0.113 4.819e-06 0.113 \
4.81902e-06 0.1125 4.823e-06 0.1125 4.82302e-06 0.1135 4.827e-06 0.1135 4.82702e-06 0.1115 4.831e-06 0.1115 4.83102e-06 0.11225 4.835e-06 0.11225 4.83502e-06 0.113 4.839e-06 0.113 4.83902e-06 0.1125 4.843e-06 0.1125 \
4.84302e-06 0.11275 4.847e-06 0.11275 4.84702e-06 0.11225 4.851e-06 0.11225 4.85102e-06 0.112 4.855e-06 0.112 4.85502e-06 0.1115 4.859e-06 0.1115 4.85902e-06 0.111 4.863e-06 0.111 4.86302e-06 0.114 4.867e-06 0.114 \
4.86702e-06 0.1135 4.871e-06 0.1135 4.87102e-06 0.113 4.875e-06 0.113 4.87502e-06 0.1135 4.879e-06 0.1135 4.87902e-06 0.1125 4.883e-06 0.1125 4.88302e-06 0.111 4.887e-06 0.111 4.88702e-06 0.114 4.891e-06 0.114 \
4.89102e-06 0.1115 4.895e-06 0.1115 4.89502e-06 0.11225 4.899e-06 0.11225 4.89902e-06 0.112 4.903e-06 0.112 4.90302e-06 0.11275 4.907e-06 0.11275 4.90702e-06 0.11225 4.911e-06 0.11225 4.91102e-06 0.1115 4.915e-06 0.1115 \
4.91502e-06 0.1125 4.919e-06 0.1125 4.91902e-06 0.113 4.923e-06 0.113 4.92302e-06 0.114 4.927e-06 0.114 4.92702e-06 0.112 4.931e-06 0.112 4.93102e-06 0.11275 4.935e-06 0.11275 4.93502e-06 0.111 4.939e-06 0.111 \
4.93902e-06 0.1135 4.943e-06 0.1135 4.94302e-06 0.11225 4.947e-06 0.11225 4.94702e-06 0.111 4.951e-06 0.111 4.95102e-06 0.113 4.955e-06 0.113 4.95502e-06 0.1115 4.959e-06 0.1115 4.95902e-06 0.1125 4.963e-06 0.1125 \
4.96302e-06 0.11275 4.967e-06 0.11275 4.96702e-06 0.114 4.971e-06 0.114 4.97102e-06 0.112 4.975e-06 0.112 4.97502e-06 0.1135 4.979e-06 0.1135 4.97902e-06 0.113 4.983e-06 0.113 4.98302e-06 0.1135 4.987e-06 0.1135 \
4.98702e-06 0.114 4.991e-06 0.114 4.99102e-06 0.112 4.995e-06 0.112 4.99502e-06 0.11275 4.999e-06 0.11275 4.99902e-06 0.111 5.003e-06 0.111 5.00302e-06 0.1125 5.007e-06 0.1125 5.00702e-06 0.11225 5.011e-06 0.11225 \
5.01102e-06 0.1115 5.015e-06 0.1115 5.01502e-06 0.1125 5.019e-06 0.1125 5.01902e-06 0.112 5.023e-06 0.112 5.02302e-06 0.11275 5.027e-06 0.11275 5.02702e-06 0.114 5.031e-06 0.114 5.03102e-06 0.1135 5.035e-06 0.1135 \
5.03502e-06 0.1115 5.039e-06 0.1115 5.03902e-06 0.113 5.043e-06 0.113 5.04302e-06 0.11225 5.047e-06 0.11225 5.04702e-06 0.111 5.051e-06 0.111 5.05102e-06 0.113 5.055e-06 0.113 5.05502e-06 0.112 5.059e-06 0.112 \
5.05902e-06 0.1125 5.063e-06 0.1125 5.06302e-06 0.11225 5.067e-06 0.11225 5.06702e-06 0.1135 5.071e-06 0.1135 5.07102e-06 0.11275 5.075e-06 0.11275 5.07502e-06 0.114 5.079e-06 0.114 5.07902e-06 0.111 5.083e-06 0.111 \
5.08302e-06 0.1115 5.087e-06 0.1115 5.08702e-06 0.111 5.091e-06 0.111 5.09102e-06 0.11225 5.095e-06 0.11225 5.09502e-06 0.1125 5.099e-06 0.1125 5.09902e-06 0.113 5.103e-06 0.113 5.10302e-06 0.11275 5.107e-06 0.11275 \
5.10702e-06 0.1115 5.111e-06 0.1115 5.11102e-06 0.1135 5.115e-06 0.1135 5.11502e-06 0.114 5.119e-06 0.114 5.11902e-06 0.112 5.123e-06 0.112 5.12302e-06 0.11275 5.127e-06 0.11275 5.12702e-06 0.1135 5.131e-06 0.1135 \
5.13102e-06 0.111 5.135e-06 0.111 5.13502e-06 0.1125 5.139e-06 0.1125 5.13902e-06 0.112 5.143e-06 0.112 5.14302e-06 0.11225 5.147e-06 0.11225 5.14702e-06 0.1115 5.151e-06 0.1115 5.15102e-06 0.114 5.155e-06 0.114 \
5.15502e-06 0.113 5.159e-06 0.113 5.15902e-06 0.114 5.163e-06 0.114 5.16302e-06 0.1125 5.167e-06 0.1125 5.16702e-06 0.11275 5.171e-06 0.11275 5.17102e-06 0.11225 5.175e-06 0.11225 5.17502e-06 0.112 5.179e-06 0.112 \
5.17902e-06 0.1115 5.183e-06 0.1115 5.18302e-06 0.1135 5.187e-06 0.1135 5.18702e-06 0.111 5.191e-06 0.111 5.19102e-06 0.113 5.195e-06 0.113 5.19502e-06 0.1125 5.199e-06 0.1125 5.19902e-06 0.113 5.203e-06 0.113 \
5.20302e-06 0.11225 5.207e-06 0.11225 5.20702e-06 0.1115 5.211e-06 0.1115 5.21102e-06 0.1135 5.215e-06 0.1135 5.21502e-06 0.11275 5.219e-06 0.11275 5.21902e-06 0.114 5.223e-06 0.114 5.22302e-06 0.111 5.227e-06 0.111 \
5.22702e-06 0.112 5.231e-06 0.112 5.23102e-06 0.11275 5.235e-06 0.11275 5.23502e-06 0.1125 5.239e-06 0.1125 5.23902e-06 0.1115 5.243e-06 0.1115 5.24302e-06 0.113 5.247e-06 0.113 5.24702e-06 0.1135 5.251e-06 0.1135 \
5.25102e-06 0.111 5.255e-06 0.111 5.25502e-06 0.114 5.259e-06 0.114 5.25902e-06 0.112 5.263e-06 0.112 5.26302e-06 0.11225 5.267e-06 0.11225 5.26702e-06 0.1115 5.271e-06 0.1115 5.27102e-06 0.112 5.275e-06 0.112 \
5.27502e-06 0.11225 5.279e-06 0.11225 5.27902e-06 0.1135 5.283e-06 0.1135 5.28302e-06 0.114 5.287e-06 0.114 5.28702e-06 0.113 5.291e-06 0.113 5.29102e-06 0.111 5.295e-06 0.111 5.29502e-06 0.11275 5.299e-06 0.11275 \
5.29902e-06 0.1125 5.303e-06 0.1125 5.30302e-06 0.112 5.307e-06 0.112 5.30702e-06 0.113 5.311e-06 0.113 5.31102e-06 0.11275 5.315e-06 0.11275 5.31502e-06 0.114 5.319e-06 0.114 5.31902e-06 0.1125 5.323e-06 0.1125 \
5.32302e-06 0.1115 5.327e-06 0.1115 5.32702e-06 0.111 5.331e-06 0.111 5.33102e-06 0.11225 5.335e-06 0.11225 5.33502e-06 0.1135 5.339e-06 0.1135 5.33902e-06 0.111 5.343e-06 0.111 5.34302e-06 0.1135 5.347e-06 0.1135 \
5.34702e-06 0.1125 5.351e-06 0.1125 5.35102e-06 0.1115 5.355e-06 0.1115 5.35502e-06 0.11275 5.359e-06 0.11275 5.35902e-06 0.114 5.363e-06 0.114 5.36302e-06 0.113 5.367e-06 0.113 5.36702e-06 0.112 5.371e-06 0.112 \
5.37102e-06 0.11225 5.375e-06 0.11225 5.37502e-06 0.113 5.379e-06 0.113 5.37902e-06 0.1115 5.383e-06 0.1115 5.38302e-06 0.1125 5.387e-06 0.1125 5.38702e-06 0.11275 5.391e-06 0.11275 5.39102e-06 0.1135 5.395e-06 0.1135 \
5.39502e-06 0.114 5.399e-06 0.114 5.39902e-06 0.112 5.403e-06 0.112 5.40302e-06 0.111 5.407e-06 0.111 5.40702e-06 0.11225 5.411e-06 0.11225 5.41102e-06 0.11225 5.415e-06 0.11225 5.41502e-06 0.1135 5.419e-06 0.1135 \
5.41902e-06 0.111 5.423e-06 0.111 5.42302e-06 0.113 5.427e-06 0.113 5.42702e-06 0.1125 5.431e-06 0.1125 5.43102e-06 0.11275 5.435e-06 0.11275 5.43502e-06 0.1115 5.439e-06 0.1115 5.43902e-06 0.112 5.443e-06 0.112 \
5.44302e-06 0.114 5.447e-06 0.114 5.44702e-06 0.113 5.451e-06 0.113 5.45102e-06 0.11225 5.455e-06 0.11225 5.45502e-06 0.114 5.459e-06 0.114 5.45902e-06 0.112 5.463e-06 0.112 5.46302e-06 0.1115 5.467e-06 0.1115 \
5.46702e-06 0.1135 5.471e-06 0.1135 5.47102e-06 0.11275 5.475e-06 0.11275 5.47502e-06 0.1125 5.479e-06 0.1125 5.47902e-06 0.111 5.483e-06 0.111 5.48302e-06 0.11275 5.487e-06 0.11275 5.48702e-06 0.1125 5.491e-06 0.1125 \
5.49102e-06 0.114 5.495e-06 0.114 5.49502e-06 0.1115 5.499e-06 0.1115 5.49902e-06 0.111 5.503e-06 0.111 5.50302e-06 0.11225 5.507e-06 0.11225 5.50702e-06 0.113 5.511e-06 0.113 5.51102e-06 0.1135 5.515e-06 0.1135 \
5.51502e-06 0.112 5.519e-06 0.112 5.51902e-06 0.1125 5.523e-06 0.1125 5.52302e-06 0.11225 5.527e-06 0.11225 5.52702e-06 0.114 5.531e-06 0.114 5.53102e-06 0.112 5.535e-06 0.112 5.53502e-06 0.11275 5.539e-06 0.11275 \
5.53902e-06 0.1115 5.543e-06 0.1115 5.54302e-06 0.111 5.547e-06 0.111 5.54702e-06 0.113 5.551e-06 0.113 5.55102e-06 0.1135 5.555e-06 0.1135 5.55502e-06 0.1125 5.559e-06 0.1125 5.55902e-06 0.1115 5.563e-06 0.1115 \
5.56302e-06 0.113 5.567e-06 0.113 5.56702e-06 0.114 5.571e-06 0.114 5.57102e-06 0.11225 5.575e-06 0.11225 5.57502e-06 0.112 5.579e-06 0.112 5.57902e-06 0.11275 5.583e-06 0.11275 5.58302e-06 0.1135 5.587e-06 0.1135 \
5.58702e-06 0.111 5.591e-06 0.111 5.59102e-06 0.114 5.595e-06 0.114 5.59502e-06 0.1135 5.599e-06 0.1135 5.59902e-06 0.1115 5.603e-06 0.1115 5.60302e-06 0.11275 5.607e-06 0.11275 5.60702e-06 0.1125 5.611e-06 0.1125 \
5.61102e-06 0.113 5.615e-06 0.113 5.61502e-06 0.111 5.619e-06 0.111 5.61902e-06 0.112 5.623e-06 0.112 5.62302e-06 0.11225 5.627e-06 0.11225 5.62702e-06 0.114 5.631e-06 0.114 5.63102e-06 0.11225 5.635e-06 0.11225 \
5.63502e-06 0.1135 5.639e-06 0.1135 5.63902e-06 0.1115 5.643e-06 0.1115 5.64302e-06 0.1125 5.647e-06 0.1125 5.64702e-06 0.113 5.651e-06 0.113 5.65102e-06 0.11275 5.655e-06 0.11275 5.65502e-06 0.112 5.659e-06 0.112 \
5.65902e-06 0.111 5.663e-06 0.111 5.66302e-06 0.111 5.667e-06 0.111 5.66702e-06 0.1125 5.671e-06 0.1125 5.67102e-06 0.113 5.675e-06 0.113 5.67502e-06 0.112 5.679e-06 0.112 5.67902e-06 0.11225 5.683e-06 0.11225 \
5.68302e-06 0.1115 5.687e-06 0.1115 5.68702e-06 0.11275 5.691e-06 0.11275 5.69102e-06 0.1135 5.695e-06 0.1135 5.69502e-06 0.114 5.699e-06 0.114 5.69902e-06 0.111 5.703e-06 0.111 5.70302e-06 0.1115 5.707e-06 0.1115 \
5.70702e-06 0.114 5.711e-06 0.114 5.71102e-06 0.1125 5.715e-06 0.1125 5.71502e-06 0.113 5.719e-06 0.113 5.71902e-06 0.11275 5.723e-06 0.11275 5.72302e-06 0.11225 5.727e-06 0.11225 5.72702e-06 0.112 5.731e-06 0.112 \
5.73102e-06 0.1135 5.735e-06 0.1135 5.73502e-06 0.113 5.739e-06 0.113 5.73902e-06 0.111 5.743e-06 0.111 5.74302e-06 0.1125 5.747e-06 0.1125 5.74702e-06 0.1135 5.751e-06 0.1135 5.75102e-06 0.11225 5.755e-06 0.11225 \
5.75502e-06 0.1115 5.759e-06 0.1115 5.75902e-06 0.11275 5.763e-06 0.11275 5.76302e-06 0.114 5.767e-06 0.114 5.76702e-06 0.112 5.771e-06 0.112 5.77102e-06 0.1115 5.775e-06 0.1115 5.77502e-06 0.11225 5.779e-06 0.11225 \
5.77902e-06 0.112 5.783e-06 0.112 5.78302e-06 0.11275 5.787e-06 0.11275 5.78702e-06 0.1135 5.791e-06 0.1135 5.79102e-06 0.111 5.795e-06 0.111 5.79502e-06 0.114 5.799e-06 0.114 5.79902e-06 0.1125 5.803e-06 0.1125 \
5.80302e-06 0.113 5.807e-06 0.113 5.80702e-06 0.11275 5.811e-06 0.11275 5.81102e-06 0.1125 5.815e-06 0.1125 5.81502e-06 0.1115 5.819e-06 0.1115 5.81902e-06 0.11225 5.823e-06 0.11225 5.82302e-06 0.113 5.827e-06 0.113 \
5.82702e-06 0.111 5.831e-06 0.111 5.83102e-06 0.114 5.835e-06 0.114 5.83502e-06 0.1135 5.839e-06 0.1135 5.83902e-06 0.112 5.843e-06 0.112 5.84302e-06 0.111 5.847e-06 0.111 5.84702e-06 0.112 5.851e-06 0.112 \
5.85102e-06 0.11225 5.855e-06 0.11225 5.85502e-06 0.1135 5.859e-06 0.1135 5.85902e-06 0.1115 5.863e-06 0.1115 5.86302e-06 0.114 5.867e-06 0.114 5.86702e-06 0.113 5.871e-06 0.113 5.87102e-06 0.1125 5.875e-06 0.1125 \
5.87502e-06 0.11275 5.879e-06 0.11275 5.87902e-06 0.112 5.883e-06 0.112 5.88302e-06 0.113 5.887e-06 0.113 5.88702e-06 0.114 5.891e-06 0.114 5.89102e-06 0.1135 5.895e-06 0.1135 5.89502e-06 0.11225 5.899e-06 0.11225 \
5.89902e-06 0.111 5.903e-06 0.111 5.90302e-06 0.11275 5.907e-06 0.11275 5.90702e-06 0.1115 5.911e-06 0.1115 5.91102e-06 0.1125 5.915e-06 0.1125 5.91502e-06 0.1125 5.919e-06 0.1125 5.91902e-06 0.113 5.923e-06 0.113 \
5.92302e-06 0.1135 5.927e-06 0.1135 5.92702e-06 0.114 5.931e-06 0.114 5.93102e-06 0.111 5.935e-06 0.111 5.93502e-06 0.11225 5.939e-06 0.11225 5.93902e-06 0.1115 5.943e-06 0.1115 5.94302e-06 0.112 5.947e-06 0.112 \
5.94702e-06 0.11275 5.951e-06 0.11275 5.95102e-06 0.11275 5.955e-06 0.11275 5.95502e-06 0.1115 5.959e-06 0.1115 5.95902e-06 0.112 5.963e-06 0.112 5.96302e-06 0.1125 5.967e-06 0.1125 5.96702e-06 0.11225 5.971e-06 0.11225 \
5.97102e-06 0.1135 5.975e-06 0.1135 5.97502e-06 0.113 5.979e-06 0.113 5.97902e-06 0.114 5.983e-06 0.114 5.98302e-06 0.111 5.987e-06 0.111 5.98702e-06 0.1115 5.991e-06 0.1115 5.99102e-06 0.11225 5.995e-06 0.11225 \
5.99502e-06 0.112 5.999e-06 0.112 5.99902e-06 0.113 6.003e-06 0.113 6.00302e-06 0.111 6.007e-06 0.111 6.00702e-06 0.114 6.011e-06 0.114 6.01102e-06 0.11275 6.015e-06 0.11275 6.01502e-06 0.1135 6.019e-06 0.1135 \
6.01902e-06 0.1125 6.023e-06 0.1125 6.02302e-06 0.1125 6.027e-06 0.1125 6.02702e-06 0.11225 6.031e-06 0.11225 6.03102e-06 0.11275 6.035e-06 0.11275 6.03502e-06 0.112 6.039e-06 0.112 6.03902e-06 0.113 6.043e-06 0.113 \
6.04302e-06 0.111 6.047e-06 0.111 6.04702e-06 0.1115 6.051e-06 0.1115 6.05102e-06 0.1135 6.055e-06 0.1135 6.05502e-06 0.114 6.059e-06 0.114 6.05902e-06 0.1115 6.063e-06 0.1115 6.06302e-06 0.1135 6.067e-06 0.1135 \
6.06702e-06 0.11275 6.071e-06 0.11275 6.07102e-06 0.1125 6.075e-06 0.1125 6.07502e-06 0.111 6.079e-06 0.111 6.07902e-06 0.113 6.083e-06 0.113 6.08302e-06 0.11225 6.087e-06 0.11225 6.08702e-06 0.112 6.091e-06 0.112 \
6.09102e-06 0.114 6.095e-06 0.114 6.09502e-06 0.1125 6.099e-06 0.1125 6.09902e-06 0.112 6.103e-06 0.112 6.10302e-06 0.113 6.107e-06 0.113 6.10702e-06 0.111 6.111e-06 0.111 6.11102e-06 0.11225 6.115e-06 0.11225 \
6.11502e-06 0.1135 6.119e-06 0.1135 6.11902e-06 0.114 6.123e-06 0.114 6.12302e-06 0.11275 6.127e-06 0.11275 6.12702e-06 0.1115 6.131e-06 0.1115 6.13102e-06 0.1135 6.135e-06 0.1135 6.13502e-06 0.1125 6.139e-06 0.1125 \
6.13902e-06 0.11225 6.143e-06 0.11225 6.14302e-06 0.114 6.147e-06 0.114 6.14702e-06 0.11275 6.151e-06 0.11275 6.15102e-06 0.113 6.155e-06 0.113 6.15502e-06 0.112 6.159e-06 0.112 6.15902e-06 0.111 6.163e-06 0.111 \
6.16302e-06 0.1115 6.167e-06 0.1115 6.16702e-06 0.112 6.171e-06 0.112 6.17102e-06 0.1125 6.175e-06 0.1125 6.17502e-06 0.11225 6.179e-06 0.11225 6.17902e-06 0.111 6.183e-06 0.111 6.18302e-06 0.113 6.187e-06 0.113 \
6.18702e-06 0.11275 6.191e-06 0.11275 6.19102e-06 0.114 6.195e-06 0.114 6.19502e-06 0.1115 6.199e-06 0.1115 6.19902e-06 0.1135 6.203e-06 0.1135 6.20302e-06 0.114 6.207e-06 0.114 6.20702e-06 0.1135 6.211e-06 0.1135 \
6.21102e-06 0.112 6.215e-06 0.112 6.21502e-06 0.111 6.219e-06 0.111 6.21902e-06 0.113 6.223e-06 0.113 6.22302e-06 0.11225 6.227e-06 0.11225 6.22702e-06 0.1115 6.231e-06 0.1115 6.23102e-06 0.11275 6.235e-06 0.11275 \
6.23502e-06 0.1125 6.239e-06 0.1125 6.23902e-06 0.1135 6.243e-06 0.1135 6.24302e-06 0.113 6.247e-06 0.113 6.24702e-06 0.11275 6.251e-06 0.11275 6.25102e-06 0.111 6.255e-06 0.111 6.25502e-06 0.11225 6.259e-06 0.11225 \
6.25902e-06 0.1115 6.263e-06 0.1115 6.26302e-06 0.1125 6.267e-06 0.1125 6.26702e-06 0.112 6.271e-06 0.112 6.27102e-06 0.114 6.275e-06 0.114 6.27502e-06 0.11275 6.279e-06 0.11275 6.27902e-06 0.1115 6.283e-06 0.1115 \
6.28302e-06 0.1135 6.287e-06 0.1135 6.28702e-06 0.1125 6.291e-06 0.1125 6.29102e-06 0.11225 6.295e-06 0.11225 6.29502e-06 0.113 6.299e-06 0.113 6.29902e-06 0.112 6.303e-06 0.112 6.30302e-06 0.111 6.307e-06 0.111 \
6.30702e-06 0.114 6.311e-06 0.114 6.31102e-06 0.1115 6.315e-06 0.1115 6.31502e-06 0.11225 6.319e-06 0.11225 6.31902e-06 0.1135 6.323e-06 0.1135 6.32302e-06 0.111 6.327e-06 0.111 6.32702e-06 0.114 6.331e-06 0.114 \
6.33102e-06 0.112 6.335e-06 0.112 6.33502e-06 0.11275 6.339e-06 0.11275 6.33902e-06 0.113 6.343e-06 0.113 6.34302e-06 0.1125 6.347e-06 0.1125 6.34702e-06 0.112 6.351e-06 0.112 6.35102e-06 0.1135 6.355e-06 0.1135 \
6.35502e-06 0.113 6.359e-06 0.113 6.35902e-06 0.111 6.363e-06 0.111 6.36302e-06 0.1115 6.367e-06 0.1115 6.36702e-06 0.11225 6.371e-06 0.11225 6.37102e-06 0.11275 6.375e-06 0.11275 6.37502e-06 0.114 6.379e-06 0.114 \
6.37902e-06 0.1125 6.383e-06 0.1125 6.38302e-06 0.1125 6.387e-06 0.1125 6.38702e-06 0.111 6.391e-06 0.111 6.39102e-06 0.112 6.395e-06 0.112 6.39502e-06 0.114 6.399e-06 0.114 6.39902e-06 0.1115 6.403e-06 0.1115 \
6.40302e-06 0.1135 6.407e-06 0.1135 6.40702e-06 0.11275 6.411e-06 0.11275 6.41102e-06 0.11225 6.415e-06 0.11225 6.41502e-06 0.113 6.419e-06 0.113 6.41902e-06 0.1125 6.423e-06 0.1125 6.42302e-06 0.114 6.427e-06 0.114 \
6.42702e-06 0.111 6.431e-06 0.111 6.43102e-06 0.11225 6.435e-06 0.11225 6.43502e-06 0.1135 6.439e-06 0.1135 6.43902e-06 0.1115 6.443e-06 0.1115 6.44302e-06 0.11275 6.447e-06 0.11275 6.44702e-06 0.112 6.451e-06 0.112 \
6.45102e-06 0.113 6.455e-06 0.113 6.45502e-06 0.11275 6.459e-06 0.11275 6.45902e-06 0.114 6.463e-06 0.114 6.46302e-06 0.112 6.467e-06 0.112 6.46702e-06 0.11225 6.471e-06 0.11225 6.47102e-06 0.1115 6.475e-06 0.1115 \
6.47502e-06 0.1135 6.479e-06 0.1135 6.47902e-06 0.1125 6.483e-06 0.1125 6.48302e-06 0.111 6.487e-06 0.111 6.48702e-06 0.113 6.491e-06 0.113 6.49102e-06 0.111 6.495e-06 0.111 6.49502e-06 0.1135 6.499e-06 0.1135 \
6.49902e-06 0.1115 6.503e-06 0.1115 6.50302e-06 0.1125 6.507e-06 0.1125 6.50702e-06 0.113 6.511e-06 0.113 6.51102e-06 0.11275 6.515e-06 0.11275 6.51502e-06 0.112 6.519e-06 0.112 6.51902e-06 0.114 6.523e-06 0.114 \
6.52302e-06 0.11225 6.527e-06 0.11225 6.52702e-06 0.11225 6.531e-06 0.11225 6.53102e-06 0.1125 6.535e-06 0.1125 6.53502e-06 0.113 6.539e-06 0.113 6.53902e-06 0.111 6.543e-06 0.111 6.54302e-06 0.114 6.547e-06 0.114 \
6.54702e-06 0.11275 6.551e-06 0.11275 6.55102e-06 0.1115 6.555e-06 0.1115 6.55502e-06 0.112 6.559e-06 0.112 6.55902e-06 0.1135 6.563e-06 0.1135 6.56302e-06 0.11225 6.567e-06 0.11225 6.56702e-06 0.113 6.571e-06 0.113 \
6.57102e-06 0.11275 6.575e-06 0.11275 6.57502e-06 0.114 6.579e-06 0.114 6.57902e-06 0.112 6.583e-06 0.112 6.58302e-06 0.1125 6.587e-06 0.1125 6.58702e-06 0.111 6.591e-06 0.111 6.59102e-06 0.1115 6.595e-06 0.1115 \
6.59502e-06 0.1135 6.599e-06 0.1135 6.59902e-06 0.11225 6.603e-06 0.11225 6.60302e-06 0.11275 6.607e-06 0.11275 6.60702e-06 0.111 6.611e-06 0.111 6.61102e-06 0.113 6.615e-06 0.113 6.61502e-06 0.112 6.619e-06 0.112 \
6.61902e-06 0.1115 6.623e-06 0.1115 6.62302e-06 0.1125 6.627e-06 0.1125 6.62702e-06 0.114 6.631e-06 0.114 6.63102e-06 0.1135 6.635e-06 0.1135 6.63502e-06 0.1115 6.639e-06 0.1115 6.63902e-06 0.1125 6.643e-06 0.1125 \
6.64302e-06 0.112 6.647e-06 0.112 6.64702e-06 0.1135 6.651e-06 0.1135 6.65102e-06 0.111 6.655e-06 0.111 6.65502e-06 0.11225 6.659e-06 0.11225 6.65902e-06 0.114 6.663e-06 0.114 6.66302e-06 0.113 6.667e-06 0.113 \
6.66702e-06 0.11275 6.671e-06 0.11275 6.67102e-06 0.11275 6.675e-06 0.11275 6.67502e-06 0.1115 6.679e-06 0.1115 6.67902e-06 0.111 6.683e-06 0.111 6.68302e-06 0.114 6.687e-06 0.114 6.68702e-06 0.1135 6.691e-06 0.1135 \
6.69102e-06 0.112 6.695e-06 0.112 6.69502e-06 0.11225 6.699e-06 0.11225 6.69902e-06 0.113 6.703e-06 0.113 6.70302e-06 0.1125 6.707e-06 0.1125 6.70702e-06 0.114 6.711e-06 0.114 6.71102e-06 0.113 6.715e-06 0.113 \
6.71502e-06 0.1125 6.719e-06 0.1125 6.71902e-06 0.112 6.723e-06 0.112 6.72302e-06 0.11225 6.727e-06 0.11225 6.72702e-06 0.11275 6.731e-06 0.11275 6.73102e-06 0.1115 6.735e-06 0.1115 6.73502e-06 0.111 6.739e-06 0.111 \
6.73902e-06 0.1135 6.743e-06 0.1135 6.74302e-06 0.11275 6.747e-06 0.11275 6.74702e-06 0.112 6.751e-06 0.112 6.75102e-06 0.11225 6.755e-06 0.11225 6.75502e-06 0.1125 6.759e-06 0.1125 6.75902e-06 0.113 6.763e-06 0.113 \
6.76302e-06 0.1115 6.767e-06 0.1115 6.76702e-06 0.1135 6.771e-06 0.1135 6.77102e-06 0.114 6.775e-06 0.114 6.77502e-06 0.111 6.779e-06 0.111 6.77902e-06 0.11225 6.783e-06 0.11225 6.78302e-06 0.1135 6.787e-06 0.1135 \
6.78702e-06 0.11275 6.791e-06 0.11275 6.79102e-06 0.112 6.795e-06 0.112 6.79502e-06 0.1115 6.799e-06 0.1115 6.79902e-06 0.114 6.803e-06 0.114 6.80302e-06 0.1125 6.807e-06 0.1125 6.80702e-06 0.113 6.811e-06 0.113 \
6.81102e-06 0.111 6.815e-06 0.111 6.81502e-06 0.11225 6.819e-06 0.11225 6.81902e-06 0.113 6.823e-06 0.113 6.82302e-06 0.1135 6.827e-06 0.1135 6.82702e-06 0.114 6.831e-06 0.114 6.83102e-06 0.1125 6.835e-06 0.1125 \
6.83502e-06 0.11275 6.839e-06 0.11275 6.83902e-06 0.1115 6.843e-06 0.1115 6.84302e-06 0.111 6.847e-06 0.111 6.84702e-06 0.112 6.851e-06 0.112 6.85102e-06 0.111 6.855e-06 0.111 6.85502e-06 0.1115 6.859e-06 0.1115 \
6.85902e-06 0.1135 6.863e-06 0.1135 6.86302e-06 0.11275 6.867e-06 0.11275 6.86702e-06 0.112 6.871e-06 0.112 6.87102e-06 0.1125 6.875e-06 0.1125 6.87502e-06 0.113 6.879e-06 0.113 6.87902e-06 0.114 6.883e-06 0.114 \
6.88302e-06 0.11225 6.887e-06 0.11225 6.88702e-06 0.111 6.891e-06 0.111 6.89102e-06 0.1125 6.895e-06 0.1125 6.89502e-06 0.112 6.899e-06 0.112 6.89902e-06 0.1115 6.903e-06 0.1115 6.90302e-06 0.11275 6.907e-06 0.11275 \
6.90702e-06 0.113 6.911e-06 0.113 6.91102e-06 0.11225 6.915e-06 0.11225 6.91502e-06 0.114 6.919e-06 0.114 6.91902e-06 0.1135 6.923e-06 0.1135 6.92302e-06 0.112 6.927e-06 0.112 6.92702e-06 0.1125 6.931e-06 0.1125 \
6.93102e-06 0.111 6.935e-06 0.111 6.93502e-06 0.1135 6.939e-06 0.1135 6.93902e-06 0.11225 6.943e-06 0.11225 6.94302e-06 0.113 6.947e-06 0.113 6.94702e-06 0.1115 6.951e-06 0.1115 6.95102e-06 0.114 6.955e-06 0.114 \
6.95502e-06 0.11275 6.959e-06 0.11275 6.95902e-06 0.111 6.963e-06 0.111 6.96302e-06 0.11275 6.967e-06 0.11275 6.96702e-06 0.114 6.971e-06 0.114 6.97102e-06 0.113 6.975e-06 0.113 6.97502e-06 0.1115 6.979e-06 0.1115 \
6.97902e-06 0.1125 6.983e-06 0.1125 6.98302e-06 0.112 6.987e-06 0.112 6.98702e-06 0.1135 6.991e-06 0.1135 6.99102e-06 0.11225 6.995e-06 0.11225 6.99502e-06 0.1125 6.999e-06 0.1125 6.99902e-06 0.1135 7.003e-06 0.1135 \
7.00302e-06 0.11275 7.007e-06 0.11275 7.00702e-06 0.1115 7.011e-06 0.1115 7.01102e-06 0.11225 7.015e-06 0.11225 7.01502e-06 0.112 7.019e-06 0.112 7.01902e-06 0.113 7.023e-06 0.113 7.02302e-06 0.111 7.027e-06 0.111 \
7.02702e-06 0.114 7.031e-06 0.114 7.03102e-06 0.1115 7.035e-06 0.1115 7.03502e-06 0.113 7.039e-06 0.113 7.03902e-06 0.11275 7.043e-06 0.11275 7.04302e-06 0.112 7.047e-06 0.112 7.04702e-06 0.111 7.051e-06 0.111 \
7.05102e-06 0.1125 7.055e-06 0.1125 7.05502e-06 0.11225 7.059e-06 0.11225 7.05902e-06 0.1135 7.063e-06 0.1135 7.06302e-06 0.114 7.067e-06 0.114 7.06702e-06 0.1135 7.071e-06 0.1135 7.07102e-06 0.114 7.075e-06 0.114 \
7.07502e-06 0.112 7.079e-06 0.112 7.07902e-06 0.1125 7.083e-06 0.1125 7.08302e-06 0.113 7.087e-06 0.113 7.08702e-06 0.11225 7.091e-06 0.11225 7.09102e-06 0.11275 7.095e-06 0.11275 7.09502e-06 0.1115 7.099e-06 0.1115 \
7.09902e-06 0.111 7.103e-06 0.111 7.10302e-06 0.111 7.107e-06 0.111 7.10702e-06 0.11275 7.111e-06 0.11275 7.11102e-06 0.1135 7.115e-06 0.1135 7.11502e-06 0.1125 7.119e-06 0.1125 7.11902e-06 0.11225 7.123e-06 0.11225 \
7.12302e-06 0.1115 7.127e-06 0.1115 7.12702e-06 0.112 7.131e-06 0.112 7.13102e-06 0.113 7.135e-06 0.113 7.13502e-06 0.114 7.139e-06 0.114 7.13902e-06 0.112 7.143e-06 0.112 7.14302e-06 0.11275 7.147e-06 0.11275 \
7.14702e-06 0.114 7.151e-06 0.114 7.15102e-06 0.1135 7.155e-06 0.1135 7.15502e-06 0.111 7.159e-06 0.111 7.15902e-06 0.1115 7.163e-06 0.1115 7.16302e-06 0.1125 7.167e-06 0.1125 7.16702e-06 0.11225 7.171e-06 0.11225 \
7.17102e-06 0.113 7.175e-06 0.113 7.17502e-06 0.1115 7.179e-06 0.1115 7.17902e-06 0.1125 7.183e-06 0.1125 7.18302e-06 0.11225 7.187e-06 0.11225 7.18702e-06 0.112 7.191e-06 0.112 7.19102e-06 0.11275 7.195e-06 0.11275 \
7.19502e-06 0.1135 7.199e-06 0.1135 7.19902e-06 0.113 7.203e-06 0.113 7.20302e-06 0.111 7.207e-06 0.111 7.20702e-06 0.114 7.211e-06 0.114 7.21102e-06 0.1125 7.215e-06 0.1125 7.21502e-06 0.1135 7.219e-06 0.1135 \
7.21902e-06 0.113 7.223e-06 0.113 7.22302e-06 0.11225 7.227e-06 0.11225 7.22702e-06 0.111 7.231e-06 0.111 7.23102e-06 0.11275 7.235e-06 0.11275 7.23502e-06 0.1115 7.239e-06 0.1115 7.23902e-06 0.112 7.243e-06 0.112 \
7.24302e-06 0.114 7.247e-06 0.114 7.24702e-06 0.11275 7.251e-06 0.11275 7.25102e-06 0.111 7.255e-06 0.111 7.25502e-06 0.1135 7.259e-06 0.1135 7.25902e-06 0.1115 7.263e-06 0.1115 7.26302e-06 0.11225 7.267e-06 0.11225 \
7.26702e-06 0.1125 7.271e-06 0.1125 7.27102e-06 0.112 7.275e-06 0.112 7.27502e-06 0.114 7.279e-06 0.114 7.27902e-06 0.113 7.283e-06 0.113 7.28302e-06 0.1135 7.287e-06 0.1135 7.28702e-06 0.11225 7.291e-06 0.11225 \
7.29102e-06 0.111 7.295e-06 0.111 7.29502e-06 0.112 7.299e-06 0.112 7.29902e-06 0.1115 7.303e-06 0.1115 7.30302e-06 0.11275 7.307e-06 0.11275 7.30702e-06 0.114 7.311e-06 0.114 7.31102e-06 0.1125 7.315e-06 0.1125 \
7.31502e-06 0.113 7.319e-06 0.113 7.31902e-06 0.113 7.323e-06 0.113 7.32302e-06 0.1135 7.327e-06 0.1135 7.32702e-06 0.11225 7.331e-06 0.11225 7.33102e-06 0.1115 7.335e-06 0.1115 7.33502e-06 0.111 7.339e-06 0.111 \
7.33902e-06 0.112 7.343e-06 0.112 7.34302e-06 0.11275 7.347e-06 0.11275 7.34702e-06 0.114 7.351e-06 0.114 7.35102e-06 0.1125 7.355e-06 0.1125 7.35502e-06 0.112 7.359e-06 0.112 7.35902e-06 0.1115 7.363e-06 0.1115 \
7.36302e-06 0.11225 7.367e-06 0.11225 7.36702e-06 0.11275 7.371e-06 0.11275 7.37102e-06 0.114 7.375e-06 0.114 7.37502e-06 0.113 7.379e-06 0.113 7.37902e-06 0.1125 7.383e-06 0.1125 7.38302e-06 0.1135 7.387e-06 0.1135 \
7.38702e-06 0.111 7.391e-06 0.111 7.39102e-06 0.111 7.395e-06 0.111 7.39502e-06 0.11275 7.399e-06 0.11275 7.39902e-06 0.1125 7.403e-06 0.1125 7.40302e-06 0.113 7.407e-06 0.113 7.40702e-06 0.1135 7.411e-06 0.1135 \
7.41102e-06 0.114 7.415e-06 0.114 7.41502e-06 0.1115 7.419e-06 0.1115 7.41902e-06 0.112 7.423e-06 0.112 7.42302e-06 0.11225 7.427e-06 0.11225 7.42702e-06 0.11275 7.431e-06 0.11275 7.43102e-06 0.1115 7.435e-06 0.1115 \
7.43502e-06 0.111 7.439e-06 0.111 7.43902e-06 0.1125 7.443e-06 0.1125 7.44302e-06 0.112 7.447e-06 0.112 7.44702e-06 0.113 7.451e-06 0.113 7.45102e-06 0.11225 7.455e-06 0.11225 7.45502e-06 0.1135 7.459e-06 0.1135 \
7.45902e-06 0.114 7.463e-06 0.114 7.46302e-06 0.1115 7.467e-06 0.1115 7.46702e-06 0.11225 7.471e-06 0.11225 7.47102e-06 0.1125 7.475e-06 0.1125 7.47502e-06 0.1135 7.479e-06 0.1135 7.47902e-06 0.113 7.483e-06 0.113 \
7.48302e-06 0.111 7.487e-06 0.111 7.48702e-06 0.112 7.491e-06 0.112 7.49102e-06 0.11275 7.495e-06 0.11275 7.49502e-06 0.114 7.499e-06 0.114 7.49902e-06 0.111 7.503e-06 0.111 7.50302e-06 0.1125 7.507e-06 0.1125 \
7.50702e-06 0.1135 7.511e-06 0.1135 7.51102e-06 0.114 7.515e-06 0.114 7.51502e-06 0.1115 7.519e-06 0.1115 7.51902e-06 0.11275 7.523e-06 0.11275 7.52302e-06 0.113 7.527e-06 0.113 7.52702e-06 0.112 7.531e-06 0.112 \
7.53102e-06 0.11225 7.535e-06 0.11225 7.53502e-06 0.112 7.539e-06 0.112 7.53902e-06 0.113 7.543e-06 0.113 7.54302e-06 0.11275 7.547e-06 0.11275 7.54702e-06 0.114 7.551e-06 0.114 7.55102e-06 0.111 7.555e-06 0.111 \
7.55502e-06 0.1125 7.559e-06 0.1125 7.55902e-06 0.11225 7.563e-06 0.11225 7.56302e-06 0.1115 7.567e-06 0.1115 7.56702e-06 0.1135 7.571e-06 0.1135 7.57102e-06 0.114 7.575e-06 0.114 7.57502e-06 0.1125 7.579e-06 0.1125 \
7.57902e-06 0.11275 7.583e-06 0.11275 7.58302e-06 0.111 7.587e-06 0.111 7.58702e-06 0.11225 7.591e-06 0.11225 7.59102e-06 0.113 7.595e-06 0.113 7.59502e-06 0.1135 7.599e-06 0.1135 7.59902e-06 0.1115 7.603e-06 0.1115 \
7.60302e-06 0.112 7.607e-06 0.112 7.60702e-06 0.1125 7.611e-06 0.1125 7.61102e-06 0.113 7.615e-06 0.113 7.61502e-06 0.11225 7.619e-06 0.11225 7.61902e-06 0.11275 7.623e-06 0.11275 7.62302e-06 0.1115 7.627e-06 0.1115 \
7.62702e-06 0.112 7.631e-06 0.112 7.63102e-06 0.1135 7.635e-06 0.1135 7.63502e-06 0.114 7.639e-06 0.114 7.63902e-06 0.111 7.643e-06 0.111 7.64302e-06 0.111 7.647e-06 0.111 7.64702e-06 0.1135 7.651e-06 0.1135 \
7.65102e-06 0.113 7.655e-06 0.113 7.65502e-06 0.11225 7.659e-06 0.11225 7.65902e-06 0.1125 7.663e-06 0.1125 7.66302e-06 0.112 7.667e-06 0.112 7.66702e-06 0.11275 7.671e-06 0.11275 7.67102e-06 0.1115 7.675e-06 0.1115 \
7.67502e-06 0.114 7.679e-06 0.114 7.67902e-06 0.112 7.683e-06 0.112 7.68302e-06 0.1135 7.687e-06 0.1135 7.68702e-06 0.114 7.691e-06 0.114 7.69102e-06 0.1115 7.695e-06 0.1115 7.69502e-06 0.1125 7.699e-06 0.1125 \
7.69902e-06 0.113 7.703e-06 0.113 7.70302e-06 0.11275 7.707e-06 0.11275 7.70702e-06 0.111 7.711e-06 0.111 7.71102e-06 0.11225 7.715e-06 0.11225 7.71502e-06 0.1115 7.719e-06 0.1115 7.71902e-06 0.11275 7.723e-06 0.11275 \
7.72302e-06 0.111 7.727e-06 0.111 7.72702e-06 0.113 7.731e-06 0.113 7.73102e-06 0.11225 7.735e-06 0.11225 7.73502e-06 0.112 7.739e-06 0.112 7.73902e-06 0.114 7.743e-06 0.114 7.74302e-06 0.1135 7.747e-06 0.1135 \
7.74702e-06 0.1125 7.751e-06 0.1125 7.75102e-06 0.114 7.755e-06 0.114 7.75502e-06 0.1115 7.759e-06 0.1115 7.75902e-06 0.11225 7.763e-06 0.11225 7.76302e-06 0.1135 7.767e-06 0.1135 7.76702e-06 0.111 7.771e-06 0.111 \
7.77102e-06 0.11275 7.775e-06 0.11275 7.77502e-06 0.113 7.779e-06 0.113 7.77902e-06 0.112 7.783e-06 0.112 7.78302e-06 0.1125 7.787e-06 0.1125 7.78702e-06 0.111 7.791e-06 0.111 7.79102e-06 0.113 7.795e-06 0.113 \
7.79502e-06 0.1135 7.799e-06 0.1135 7.79902e-06 0.11225 7.803e-06 0.11225 7.80302e-06 0.11275 7.807e-06 0.11275 7.80702e-06 0.1125 7.811e-06 0.1125 7.81102e-06 0.112 7.815e-06 0.112 7.81502e-06 0.1115 7.819e-06 0.1115 \
7.81902e-06 0.114 7.823e-06 0.114 7.82302e-06 0.113 7.827e-06 0.113 7.82702e-06 0.11225 7.831e-06 0.11225 7.83102e-06 0.1135 7.835e-06 0.1135 7.83502e-06 0.114 7.839e-06 0.114 7.83902e-06 0.112 7.843e-06 0.112 \
7.84302e-06 0.11275 7.847e-06 0.11275 7.84702e-06 0.111 7.851e-06 0.111 7.85102e-06 0.1125 7.855e-06 0.1125 7.85502e-06 0.1115 7.859e-06 0.1115 7.85902e-06 0.1125 7.863e-06 0.1125 7.86302e-06 0.11275 7.867e-06 0.11275 \
7.86702e-06 0.11225 7.871e-06 0.11225 7.87102e-06 0.112 7.875e-06 0.112 7.87502e-06 0.1135 7.879e-06 0.1135 7.87902e-06 0.111 7.883e-06 0.111 7.88302e-06 0.113 7.887e-06 0.113 7.88702e-06 0.1115 7.891e-06 0.1115 \
7.89102e-06 0.114 7.895e-06 0.114 7.89502e-06 0.11275 7.899e-06 0.11275 7.89902e-06 0.111 7.903e-06 0.111 7.90302e-06 0.1115 7.907e-06 0.1115 7.90702e-06 0.113 7.911e-06 0.113 7.91102e-06 0.114 7.915e-06 0.114 \
7.91502e-06 0.1125 7.919e-06 0.1125 7.91902e-06 0.112 7.923e-06 0.112 7.92302e-06 0.1135 7.927e-06 0.1135 7.92702e-06 0.11225 7.931e-06 0.11225 7.93102e-06 0.114 7.935e-06 0.114 7.93502e-06 0.1125 7.939e-06 0.1125 \
7.93902e-06 0.113 7.943e-06 0.113 7.94302e-06 0.112 7.947e-06 0.112 7.94702e-06 0.111 7.951e-06 0.111 7.95102e-06 0.1135 7.955e-06 0.1135 7.95502e-06 0.1115 7.959e-06 0.1115 7.95902e-06 0.11275 7.963e-06 0.11275 \
7.96302e-06 0.11225 7.967e-06 0.11225 7.96702e-06 0.11225 7.971e-06 0.11225 7.97102e-06 0.1115 7.975e-06 0.1115 7.97502e-06 0.1135 7.979e-06 0.1135 7.97902e-06 0.1125 7.983e-06 0.1125 7.98302e-06 0.111 7.987e-06 0.111 \
7.98702e-06 0.114 7.991e-06 0.114 7.99102e-06 0.11275 7.995e-06 0.11275 7.99502e-06 0.113 7.999e-06 0.113 7.99902e-06 0.112 8.003e-06 0.112 8.00302e-06 0.11225 8.007e-06 0.11225 8.00702e-06 0.113 8.011e-06 0.113 \
8.01102e-06 0.1135 8.015e-06 0.1135 8.01502e-06 0.11275 8.019e-06 0.11275 8.01902e-06 0.111 8.023e-06 0.111 8.02302e-06 0.1115 8.027e-06 0.1115 8.02702e-06 0.112 8.031e-06 0.112 8.03102e-06 0.114 8.035e-06 0.114 \
8.03502e-06 0.1125 8.039e-06 0.1125 8.03902e-06 0.1135 8.043e-06 0.1135 8.04302e-06 0.11225 8.047e-06 0.11225 8.04702e-06 0.112 8.051e-06 0.112 8.05102e-06 0.114 8.055e-06 0.114 8.05502e-06 0.1115 8.059e-06 0.1115 \
8.05902e-06 0.1125 8.063e-06 0.1125 8.06302e-06 0.11275 8.067e-06 0.11275 8.06702e-06 0.113 8.071e-06 0.113 8.07102e-06 0.111 8.075e-06 0.111 8.07502e-06 0.11225 8.079e-06 0.11225 8.07902e-06 0.114 8.083e-06 0.114 \
8.08302e-06 0.111 8.087e-06 0.111 8.08702e-06 0.112 8.091e-06 0.112 8.09102e-06 0.1125 8.095e-06 0.1125 8.09502e-06 0.1115 8.099e-06 0.1115 8.09902e-06 0.1135 8.103e-06 0.1135 8.10302e-06 0.113 8.107e-06 0.113 \
8.10702e-06 0.11275 8.111e-06 0.11275 8.11102e-06 0.11225 8.115e-06 0.11225 8.11502e-06 0.114 8.119e-06 0.114 8.11902e-06 0.113 8.123e-06 0.113 8.12302e-06 0.112 8.127e-06 0.112 8.12702e-06 0.11275 8.131e-06 0.11275 \
8.13102e-06 0.1115 8.135e-06 0.1115 8.13502e-06 0.1125 8.139e-06 0.1125 8.13902e-06 0.1135 8.143e-06 0.1135 8.14302e-06 0.111 8.147e-06 0.111 8.14702e-06 0.1115 8.151e-06 0.1115 8.15102e-06 0.111 8.155e-06 0.111 \
8.15502e-06 0.112 8.159e-06 0.112 8.15902e-06 0.1135 8.163e-06 0.1135 8.16302e-06 0.1125 8.167e-06 0.1125 8.16702e-06 0.114 8.171e-06 0.114 8.17102e-06 0.113 8.175e-06 0.113 8.17502e-06 0.11225 8.179e-06 0.11225 \
8.17902e-06 0.11275 8.183e-06 0.11275 8.18302e-06 0.1115 8.187e-06 0.1115 8.18702e-06 0.1125 8.191e-06 0.1125 8.19102e-06 0.113 8.195e-06 0.113 8.19502e-06 0.112 8.199e-06 0.112 8.19902e-06 0.114 8.203e-06 0.114 \
8.20302e-06 0.111 8.207e-06 0.111 8.20702e-06 0.11225 8.211e-06 0.11225 8.21102e-06 0.1135 8.215e-06 0.1135 8.21502e-06 0.11275 8.219e-06 0.11275 8.21902e-06 0.1115 8.223e-06 0.1115 8.22302e-06 0.114 8.227e-06 0.114 \
8.22702e-06 0.112 8.231e-06 0.112 8.23102e-06 0.11275 8.235e-06 0.11275 8.23502e-06 0.1135 8.239e-06 0.1135 8.23902e-06 0.1125 8.243e-06 0.1125 8.24302e-06 0.111 8.247e-06 0.111 8.24702e-06 0.11225 8.251e-06 0.11225 \
8.25102e-06 0.113 8.255e-06 0.113 8.25502e-06 0.11275 8.259e-06 0.11275 8.25902e-06 0.114 8.263e-06 0.114 8.26302e-06 0.112 8.267e-06 0.112 8.26702e-06 0.11225 8.271e-06 0.11225 8.27102e-06 0.1125 8.275e-06 0.1125 \
8.27502e-06 0.1115 8.279e-06 0.1115 8.27902e-06 0.1135 8.283e-06 0.1135 8.28302e-06 0.111 8.287e-06 0.111 8.28702e-06 0.113 8.291e-06 0.113 8.29102e-06 0.11275 8.295e-06 0.11275 8.29502e-06 0.1135 8.299e-06 0.1135 \
8.29902e-06 0.113 8.303e-06 0.113 8.30302e-06 0.1125 8.307e-06 0.1125 8.30702e-06 0.114 8.311e-06 0.114 8.31102e-06 0.11225 8.315e-06 0.11225 8.31502e-06 0.111 8.319e-06 0.111 8.31902e-06 0.112 8.323e-06 0.112 \
8.32302e-06 0.1115 8.327e-06 0.1115 8.32702e-06 0.1125 8.331e-06 0.1125 8.33102e-06 0.113 8.335e-06 0.113 8.33502e-06 0.112 8.339e-06 0.112 8.33902e-06 0.1135 8.343e-06 0.1135 8.34302e-06 0.114 8.347e-06 0.114 \
8.34702e-06 0.11275 8.351e-06 0.11275 8.35102e-06 0.1115 8.355e-06 0.1115 8.35502e-06 0.111 8.359e-06 0.111 8.35902e-06 0.11225 8.363e-06 0.11225 8.36302e-06 0.111 8.367e-06 0.111 8.36702e-06 0.1135 8.371e-06 0.1135 \
8.37102e-06 0.113 8.375e-06 0.113 8.37502e-06 0.1115 8.379e-06 0.1115 8.37902e-06 0.112 8.383e-06 0.112 8.38302e-06 0.11275 8.387e-06 0.11275 8.38702e-06 0.114 8.391e-06 0.114 8.39102e-06 0.11225 8.395e-06 0.11225 \
8.39502e-06 0.1125 8.399e-06 0.1125 8.39902e-06 0.11275 8.403e-06 0.11275 8.40302e-06 0.1135 8.407e-06 0.1135 8.40702e-06 0.112 8.411e-06 0.112 8.41102e-06 0.1115 8.415e-06 0.1115 8.41502e-06 0.113 8.419e-06 0.113 \
8.41902e-06 0.114 8.423e-06 0.114 8.42302e-06 0.11225 8.427e-06 0.11225 8.42702e-06 0.1125 8.431e-06 0.1125 8.43102e-06 0.111 8.435e-06 0.111 8.43502e-06 0.1115 8.439e-06 0.1115 8.43902e-06 0.1135 8.443e-06 0.1135 \
8.44302e-06 0.1125 8.447e-06 0.1125 8.44702e-06 0.114 8.451e-06 0.114 8.45102e-06 0.112 8.455e-06 0.112 8.45502e-06 0.11275 8.459e-06 0.11275 8.45902e-06 0.111 8.463e-06 0.111 8.46302e-06 0.113 8.467e-06 0.113 \
8.46702e-06 0.11225 8.471e-06 0.11225 8.47102e-06 0.11225 8.475e-06 0.11225 8.47502e-06 0.11275 8.479e-06 0.11275 8.47902e-06 0.1115 8.483e-06 0.1115 8.48302e-06 0.113 8.487e-06 0.113 8.48702e-06 0.1125 8.491e-06 0.1125 \
8.49102e-06 0.111 8.495e-06 0.111 8.49502e-06 0.114 8.499e-06 0.114 8.49902e-06 0.1135 8.503e-06 0.1135 8.50302e-06 0.112 8.507e-06 0.112 8.50702e-06 0.1115 8.511e-06 0.1115 8.51102e-06 0.113 8.515e-06 0.113 \
8.51502e-06 0.114 8.519e-06 0.114 8.51902e-06 0.112 8.523e-06 0.112 8.52302e-06 0.11225 8.527e-06 0.11225 8.52702e-06 0.111 8.531e-06 0.111 8.53102e-06 0.1135 8.535e-06 0.1135 8.53502e-06 0.11275 8.539e-06 0.11275 \
8.53902e-06 0.1125 8.543e-06 0.1125 8.54302e-06 0.11225 8.547e-06 0.11225 8.54702e-06 0.1135 8.551e-06 0.1135 8.55102e-06 0.113 8.555e-06 0.113 8.55502e-06 0.112 8.559e-06 0.112 8.55902e-06 0.11275 8.563e-06 0.11275 \
8.56302e-06 0.1125 8.567e-06 0.1125 8.56702e-06 0.1115 8.571e-06 0.1115 8.57102e-06 0.111 8.575e-06 0.111 8.57502e-06 0.114 8.579e-06 0.114 8.57902e-06 0.113 8.583e-06 0.113 8.58302e-06 0.112 8.587e-06 0.112 \
8.58702e-06 0.1125 8.591e-06 0.1125 8.59102e-06 0.1135 8.595e-06 0.1135 8.59502e-06 0.1115 8.599e-06 0.1115 8.59902e-06 0.11225 8.603e-06 0.11225 8.60302e-06 0.111 8.607e-06 0.111 8.60702e-06 0.114 8.611e-06 0.114 \
8.61102e-06 0.11275 8.615e-06 0.11275 8.61502e-06 0.111 8.619e-06 0.111 8.61902e-06 0.11225 8.623e-06 0.11225 8.62302e-06 0.1125 8.627e-06 0.1125 8.62702e-06 0.114 8.631e-06 0.114 8.63102e-06 0.1135 8.635e-06 0.1135 \
8.63502e-06 0.1115 8.639e-06 0.1115 8.63902e-06 0.112 8.643e-06 0.112 8.64302e-06 0.11275 8.647e-06 0.11275 8.64702e-06 0.113 8.651e-06 0.113 8.65102e-06 0.111 8.655e-06 0.111 8.65502e-06 0.113 8.659e-06 0.113 \
8.65902e-06 0.11275 8.663e-06 0.11275 8.66302e-06 0.112 8.667e-06 0.112 8.66702e-06 0.1115 8.671e-06 0.1115 8.67102e-06 0.11225 8.675e-06 0.11225 8.67502e-06 0.114 8.679e-06 0.114 8.67902e-06 0.1135 8.683e-06 0.1135 \
8.68302e-06 0.1125 8.687e-06 0.1125 8.68702e-06 0.11275 8.691e-06 0.11275 8.69102e-06 0.113 8.695e-06 0.113 8.69502e-06 0.1125 8.699e-06 0.1125 8.69902e-06 0.112 8.703e-06 0.112 8.70302e-06 0.1115 8.707e-06 0.1115 \
8.70702e-06 0.111 8.711e-06 0.111 8.71102e-06 0.114 8.715e-06 0.114 8.71502e-06 0.11225 8.719e-06 0.11225 8.71902e-06 0.1135 8.723e-06 0.1135 8.72302e-06 0.113 8.727e-06 0.113 8.72702e-06 0.11275 8.731e-06 0.11275 \
8.73102e-06 0.1125 8.735e-06 0.1125 8.73502e-06 0.111 8.739e-06 0.111 8.73902e-06 0.11225 8.743e-06 0.11225 8.74302e-06 0.1115 8.747e-06 0.1115 8.74702e-06 0.114 8.751e-06 0.114 8.75102e-06 0.112 8.755e-06 0.112 \
8.75502e-06 0.1135 8.759e-06 0.1135 8.75902e-06 0.1115 8.763e-06 0.1115 8.76302e-06 0.113 8.767e-06 0.113 8.76702e-06 0.1125 8.771e-06 0.1125 8.77102e-06 0.1135 8.775e-06 0.1135 8.77502e-06 0.114 8.779e-06 0.114 \
8.77902e-06 0.112 8.783e-06 0.112 8.78302e-06 0.11225 8.787e-06 0.11225 8.78702e-06 0.11275 8.791e-06 0.11275 8.79102e-06 0.111 8.795e-06 0.111 8.79502e-06 0.113 8.799e-06 0.113 8.79902e-06 0.112 8.803e-06 0.112 \
8.80302e-06 0.1135 8.807e-06 0.1135 8.80702e-06 0.11225 8.811e-06 0.11225 8.81102e-06 0.1125 8.815e-06 0.1125 8.81502e-06 0.114 8.819e-06 0.114 8.81902e-06 0.1115 8.823e-06 0.1115 8.82302e-06 0.111 8.827e-06 0.111 \
8.82702e-06 0.11275 8.831e-06 0.11275 8.83102e-06 0.11225 8.835e-06 0.11225 8.83502e-06 0.1135 8.839e-06 0.1135 8.83902e-06 0.1125 8.843e-06 0.1125 8.84302e-06 0.114 8.847e-06 0.114 8.84702e-06 0.112 8.851e-06 0.112 \
8.85102e-06 0.113 8.855e-06 0.113 8.85502e-06 0.111 8.859e-06 0.111 8.85902e-06 0.1115 8.863e-06 0.1115 8.86302e-06 0.11275 8.867e-06 0.11275 8.86702e-06 0.11275 8.871e-06 0.11275 8.87102e-06 0.111 8.875e-06 0.111 \
8.87502e-06 0.112 8.879e-06 0.112 8.87902e-06 0.1125 8.883e-06 0.1125 8.88302e-06 0.11225 8.887e-06 0.11225 8.88702e-06 0.1135 8.891e-06 0.1135 8.89102e-06 0.114 8.895e-06 0.114 8.89502e-06 0.1115 8.899e-06 0.1115 \
8.89902e-06 0.113 8.903e-06 0.113 8.90302e-06 0.113 8.907e-06 0.113 8.90702e-06 0.11225 8.911e-06 0.11225 8.91102e-06 0.114 8.915e-06 0.114 8.91502e-06 0.112 8.919e-06 0.112 8.91902e-06 0.1125 8.923e-06 0.1125 \
8.92302e-06 0.111 8.927e-06 0.111 8.92702e-06 0.1115 8.931e-06 0.1115 8.93102e-06 0.1135 8.935e-06 0.1135 8.93502e-06 0.11275 8.939e-06 0.11275 8.93902e-06 0.11225 8.943e-06 0.11225 8.94302e-06 0.1135 8.947e-06 0.1135 \
8.94702e-06 0.111 8.951e-06 0.111 8.95102e-06 0.114 8.955e-06 0.114 8.95502e-06 0.113 8.959e-06 0.113 8.95902e-06 0.1115 8.963e-06 0.1115 8.96302e-06 0.11275 8.967e-06 0.11275 8.96702e-06 0.112 8.971e-06 0.112 \
8.97102e-06 0.1125 8.975e-06 0.1125 8.97502e-06 0.114 8.979e-06 0.114 8.97902e-06 0.11225 8.983e-06 0.11225 8.98302e-06 0.113 8.987e-06 0.113 8.98702e-06 0.112 8.991e-06 0.112 8.99102e-06 0.1135 8.995e-06 0.1135 \
8.99502e-06 0.1115 8.999e-06 0.1115 8.99902e-06 0.1125 9.003e-06 0.1125 9.00302e-06 0.111 9.007e-06 0.111 9.00702e-06 0.11275 9.011e-06 0.11275 9.01102e-06 0.113 9.015e-06 0.113 9.01502e-06 0.111 9.019e-06 0.111 \
9.01902e-06 0.114 9.023e-06 0.114 9.02302e-06 0.112 9.027e-06 0.112 9.02702e-06 0.1135 9.031e-06 0.1135 9.03102e-06 0.1125 9.035e-06 0.1125 9.03502e-06 0.11225 9.039e-06 0.11225 9.03902e-06 0.11275 9.043e-06 0.11275 \
9.04302e-06 0.1115 9.047e-06 0.1115 9.04702e-06 0.111 9.051e-06 0.111 9.05102e-06 0.1135 9.055e-06 0.1135 9.05502e-06 0.11275 9.059e-06 0.11275 9.05902e-06 0.11225 9.063e-06 0.11225 9.06302e-06 0.1125 9.067e-06 0.1125 \
9.06702e-06 0.112 9.071e-06 0.112 9.07102e-06 0.1115 9.075e-06 0.1115 9.07502e-06 0.113 9.079e-06 0.113 9.07902e-06 0.114 9.083e-06 0.114 9.08302e-06 0.113 9.087e-06 0.113 9.08702e-06 0.111 9.091e-06 0.111 \
9.09102e-06 0.1135 9.095e-06 0.1135 9.09502e-06 0.11225 9.099e-06 0.11225 9.09902e-06 0.1125 9.103e-06 0.1125 9.10302e-06 0.112 9.107e-06 0.112 9.10702e-06 0.1115 9.111e-06 0.1115 9.11102e-06 0.114 9.115e-06 0.114 \
9.11502e-06 0.11275 9.119e-06 0.11275 9.11902e-06 0.112 9.123e-06 0.112 9.12302e-06 0.11225 9.127e-06 0.11225 9.12702e-06 0.1135 9.131e-06 0.1135 9.13102e-06 0.113 9.135e-06 0.113 9.13502e-06 0.111 9.139e-06 0.111 \
9.13902e-06 0.1115 9.143e-06 0.1115 9.14302e-06 0.11275 9.147e-06 0.11275 9.14702e-06 0.1125 9.151e-06 0.1125 9.15102e-06 0.114 9.155e-06 0.114 9.15502e-06 0.111 9.159e-06 0.111 9.15902e-06 0.11225 9.163e-06 0.11225 \
9.16302e-06 0.11275 9.167e-06 0.11275 9.16702e-06 0.1135 9.171e-06 0.1135 9.17102e-06 0.114 9.175e-06 0.114 9.17502e-06 0.1125 9.179e-06 0.1125 9.17902e-06 0.113 9.183e-06 0.113 9.18302e-06 0.1115 9.187e-06 0.1115 \
9.18702e-06 0.112 9.191e-06 0.112 9.19102e-06 0.114 9.195e-06 0.114 9.19502e-06 0.11275 9.199e-06 0.11275 9.19902e-06 0.111 9.203e-06 0.111 9.20302e-06 0.1135 9.207e-06 0.1135 9.20702e-06 0.1115 9.211e-06 0.1115 \
9.21102e-06 0.1125 9.215e-06 0.1125 9.21502e-06 0.113 9.219e-06 0.113 9.21902e-06 0.11225 9.223e-06 0.11225 9.22302e-06 0.112 9.227e-06 0.112 9.22702e-06 0.11275 9.231e-06 0.11275 9.23102e-06 0.113 9.235e-06 0.113 \
9.23502e-06 0.114 9.239e-06 0.114 9.23902e-06 0.112 9.243e-06 0.112 9.24302e-06 0.111 9.247e-06 0.111 9.24702e-06 0.1125 9.251e-06 0.1125 9.25102e-06 0.1115 9.255e-06 0.1115 9.25502e-06 0.11225 9.259e-06 0.11225 \
9.25902e-06 0.1135 9.263e-06 0.1135 9.26302e-06 0.1135 9.267e-06 0.1135 9.26702e-06 0.11225 9.271e-06 0.11225 9.27102e-06 0.1115 9.275e-06 0.1115 9.27502e-06 0.114 9.279e-06 0.114 9.27902e-06 0.11275 9.283e-06 0.11275 \
9.28302e-06 0.112 9.287e-06 0.112 9.28702e-06 0.113 9.291e-06 0.113 9.29102e-06 0.1125 9.295e-06 0.1125 9.29502e-06 0.111 9.299e-06 0.111 9.29902e-06 0.111 9.303e-06 0.111 9.30302e-06 0.1125 9.307e-06 0.1125 \
9.30702e-06 0.1135 9.311e-06 0.1135 9.31102e-06 0.11225 9.315e-06 0.11225 9.31502e-06 0.1115 9.319e-06 0.1115 9.31902e-06 0.11275 9.323e-06 0.11275 9.32302e-06 0.112 9.327e-06 0.112 9.32702e-06 0.113 9.331e-06 0.113 \
9.33102e-06 0.114 9.335e-06 0.114 9.33502e-06 0.0015078125 9.339e-06 0.0015078125 9.33902e-06 0.0002578125 9.343e-06 0.0002578125 9.34302e-06 0.0027578125 9.347e-06 0.0027578125 9.34702e-06 0.0022578125 9.351e-06 0.0022578125 9.35102e-06 0.0012578125 9.355e-06 0.0012578125 \
9.35502e-06 0.0017578125 9.359e-06 0.0017578125 9.35902e-06 0.0020078125 9.363e-06 0.0020078125 9.36302e-06 0.0007578125 9.367e-06 0.0007578125 9.36702e-06 0.0032578125 9.371e-06 0.0032578125 9.37102e-06 0.0017578125 9.375e-06 0.0017578125 9.37502e-06 0.0027578125 9.379e-06 0.0027578125 \
9.37902e-06 0.0022578125 9.383e-06 0.0022578125 9.38302e-06 0.0032578125 9.387e-06 0.0032578125 9.38702e-06 0.0012578125 9.391e-06 0.0012578125 9.39102e-06 0.0015078125 9.395e-06 0.0015078125 9.39502e-06 0.0020078125 9.399e-06 0.0020078125 9.39902e-06 0.0007578125 9.403e-06 0.0007578125 \
9.40302e-06 0.0002578125 9.407e-06 0.0002578125 9.40702e-06 0.0020078125 9.411e-06 0.0020078125 9.41102e-06 0.0017578125 9.415e-06 0.0017578125 9.41502e-06 0.0022578125 9.419e-06 0.0022578125 9.41902e-06 0.0012578125 9.423e-06 0.0012578125 9.42302e-06 0.0015078125 9.427e-06 0.0015078125 \
9.42702e-06 0.0007578125 9.431e-06 0.0007578125 9.43102e-06 0.0027578125 9.435e-06 0.0027578125 9.43502e-06 0.0002578125 9.439e-06 0.0002578125 9.43902e-06 0.0032578125 9.443e-06 0.0032578125 9.44302e-06 0.0002578125 9.447e-06 0.0002578125 9.44702e-06 0.0012578125 9.451e-06 0.0012578125 \
9.45102e-06 0.0007578125 9.455e-06 0.0007578125 9.45502e-06 0.0015078125 9.459e-06 0.0015078125 9.45902e-06 0.0020078125 9.463e-06 0.0020078125 9.46302e-06 0.0017578125 9.467e-06 0.0017578125 9.46702e-06 0.0027578125 9.471e-06 0.0027578125 9.47102e-06 0.0022578125 9.475e-06 0.0022578125 \
9.47502e-06 0.0032578125 9.479e-06 0.0032578125 9.47902e-06 0.0032578125 9.483e-06 0.0032578125 9.48302e-06 0.0007578125 9.487e-06 0.0007578125 9.48702e-06 0.0017578125 9.491e-06 0.0017578125 9.49102e-06 0.0015078125 9.495e-06 0.0015078125 9.49502e-06 0.0002578125 9.499e-06 0.0002578125 \
9.49902e-06 0.0027578125 9.503e-06 0.0027578125 9.50302e-06 0.0012578125 9.507e-06 0.0012578125 9.50702e-06 0.0022578125 9.511e-06 0.0022578125 9.51102e-06 0.0020078125 9.515e-06 0.0020078125 9.51502e-06 0.0022578125 9.519e-06 0.0022578125 9.51902e-06 0.0017578125 9.523e-06 0.0017578125 \
9.52302e-06 0.0002578125 9.527e-06 0.0002578125 9.52702e-06 0.0012578125 9.531e-06 0.0012578125 9.53102e-06 0.0007578125 9.535e-06 0.0007578125 9.53502e-06 0.0032578125 9.539e-06 0.0032578125 9.53902e-06 0.0015078125 9.543e-06 0.0015078125 9.54302e-06 0.0027578125 9.547e-06 0.0027578125 \
9.54702e-06 0.0020078125 9.551e-06 0.0020078125 9.55102e-06 0.0027578125 9.555e-06 0.0027578125 9.55502e-06 0.0032578125 9.559e-06 0.0032578125 9.55902e-06 0.0015078125 9.563e-06 0.0015078125 9.56302e-06 0.0020078125 9.567e-06 0.0020078125 9.56702e-06 0.0007578125 9.571e-06 0.0007578125 \
9.57102e-06 0.0012578125 9.575e-06 0.0012578125 9.57502e-06 0.0022578125 9.579e-06 0.0022578125 9.57902e-06 0.0002578125 9.583e-06 0.0002578125 9.58302e-06 0.0017578125 9.587e-06 0.0017578125 9.58702e-06 0.0007578125 9.591e-06 0.0007578125 9.59102e-06 0.0027578125 9.595e-06 0.0027578125 \
9.59502e-06 0.0020078125 9.599e-06 0.0020078125 9.59902e-06 0.0015078125 9.603e-06 0.0015078125 9.60302e-06 0.0017578125 9.607e-06 0.0017578125 9.60702e-06 0.0032578125 9.611e-06 0.0032578125 9.61102e-06 0.0012578125 9.615e-06 0.0012578125 9.61502e-06 0.0002578125 9.619e-06 0.0002578125 \
9.61902e-06 0.0022578125 9.623e-06 0.0022578125 9.62302e-06 0.0015078125 9.627e-06 0.0015078125 9.62702e-06 0.0017578125 9.631e-06 0.0017578125 9.63102e-06 0.0020078125 9.635e-06 0.0020078125 9.63502e-06 0.0022578125 9.639e-06 0.0022578125 9.63902e-06 0.0027578125 9.643e-06 0.0027578125 \
9.64302e-06 0.0012578125 9.647e-06 0.0012578125 9.64702e-06 0.0002578125 9.651e-06 0.0002578125 9.65102e-06 0.0007578125 9.655e-06 0.0007578125 9.65502e-06 0.0032578125 9.659e-06 0.0032578125 9.65902e-06 0.0032578125 9.663e-06 0.0032578125 9.66302e-06 0.0020078125 9.667e-06 0.0020078125 \
9.66702e-06 0.0017578125 9.671e-06 0.0017578125 9.67102e-06 0.0002578125 9.675e-06 0.0002578125 9.67502e-06 0.0022578125 9.679e-06 0.0022578125 9.67902e-06 0.0007578125 9.683e-06 0.0007578125 9.68302e-06 0.0012578125 9.687e-06 0.0012578125 9.68702e-06 0.0027578125 9.691e-06 0.0027578125 \
9.69102e-06 0.0015078125 9.695e-06 0.0015078125 9.69502e-06 0.0015078125 9.699e-06 0.0015078125 9.69902e-06 0.0032578125 9.703e-06 0.0032578125 9.70302e-06 0.0002578125 9.707e-06 0.0002578125 9.70702e-06 0.0020078125 9.711e-06 0.0020078125 9.71102e-06 0.0017578125 9.715e-06 0.0017578125 \
9.71502e-06 0.0022578125 9.719e-06 0.0022578125 9.71902e-06 0.0012578125 9.723e-06 0.0012578125 9.72302e-06 0.0007578125 9.727e-06 0.0007578125 9.72702e-06 0.0027578125 9.731e-06 0.0027578125 9.73102e-06 0.0002578125 9.735e-06 0.0002578125 9.73502e-06 0.0032578125 9.739e-06 0.0032578125 \
9.73902e-06 0.0017578125 9.743e-06 0.0017578125 9.74302e-06 0.0020078125 9.747e-06 0.0020078125 9.74702e-06 0.0007578125 9.751e-06 0.0007578125 9.75102e-06 0.0012578125 9.755e-06 0.0012578125 9.75502e-06 0.0022578125 9.759e-06 0.0022578125 9.75902e-06 0.0027578125 9.763e-06 0.0027578125 \
9.76302e-06 0.0015078125 9.767e-06 0.0015078125 9.76702e-06 0.0020078125 9.771e-06 0.0020078125 9.77102e-06 0.0007578125 9.775e-06 0.0007578125 9.77502e-06 0.0022578125 9.779e-06 0.0022578125 9.77902e-06 0.0032578125 9.783e-06 0.0032578125 9.78302e-06 0.0012578125 9.787e-06 0.0012578125 \
9.78702e-06 0.0017578125 9.791e-06 0.0017578125 9.79102e-06 0.0027578125 9.795e-06 0.0027578125 9.79502e-06 0.0002578125 9.799e-06 0.0002578125 9.79902e-06 0.0015078125 9.803e-06 0.0015078125 9.80302e-06 0.0007578125 9.807e-06 0.0007578125 9.80702e-06 0.0015078125 9.811e-06 0.0015078125 \
9.81102e-06 0.0027578125 9.815e-06 0.0027578125 9.81502e-06 0.0017578125 9.819e-06 0.0017578125 9.81902e-06 0.0022578125 9.823e-06 0.0022578125 9.82302e-06 0.0012578125 9.827e-06 0.0012578125 9.82702e-06 0.0020078125 9.831e-06 0.0020078125 9.83102e-06 0.0002578125 9.835e-06 0.0002578125 \
9.83502e-06 0.0032578125 9.839e-06 0.0032578125 9.83902e-06 0.0022578125 9.843e-06 0.0022578125 9.84302e-06 0.0015078125 9.847e-06 0.0015078125 9.84702e-06 0.0017578125 9.851e-06 0.0017578125 9.85102e-06 0.0012578125 9.855e-06 0.0012578125 9.85502e-06 0.0032578125 9.859e-06 0.0032578125 \
9.85902e-06 0.0020078125 9.863e-06 0.0020078125 9.86302e-06 0.0002578125 9.867e-06 0.0002578125 9.86702e-06 0.0007578125 9.871e-06 0.0007578125 9.87102e-06 0.0027578125 9.875e-06 0.0027578125 9.87502e-06 0.0007578125 9.879e-06 0.0007578125 9.87902e-06 0.0012578125 9.883e-06 0.0012578125 \
9.88302e-06 0.0032578125 9.887e-06 0.0032578125 9.88702e-06 0.0017578125 9.891e-06 0.0017578125 9.89102e-06 0.0022578125 9.895e-06 0.0022578125 9.89502e-06 0.0027578125 9.899e-06 0.0027578125 9.89902e-06 0.0002578125 9.903e-06 0.0002578125 9.90302e-06 0.0020078125 9.907e-06 0.0020078125 \
9.90702e-06 0.0015078125 9.911e-06 0.0015078125 9.91102e-06 0.0015078125 9.915e-06 0.0015078125 9.91502e-06 0.0007578125 9.919e-06 0.0007578125 9.91902e-06 0.0032578125 9.923e-06 0.0032578125 9.92302e-06 0.0002578125 9.927e-06 0.0002578125 9.92702e-06 0.0022578125 9.931e-06 0.0022578125 \
9.93102e-06 0.0020078125 9.935e-06 0.0020078125 9.93502e-06 0.0012578125 9.939e-06 0.0012578125 9.93902e-06 0.0027578125 9.943e-06 0.0027578125 9.94302e-06 0.0017578125 9.947e-06 0.0017578125 9.94702e-06 0.0022578125 9.951e-06 0.0022578125 9.95102e-06 0.0015078125 9.955e-06 0.0015078125 \
9.95502e-06 0.0007578125 9.959e-06 0.0007578125 9.95902e-06 0.0020078125 9.963e-06 0.0020078125 9.96302e-06 0.0032578125 9.967e-06 0.0032578125 9.96702e-06 0.0027578125 9.971e-06 0.0027578125 9.97102e-06 0.0017578125 9.975e-06 0.0017578125 9.97502e-06 0.0012578125 9.979e-06 0.0012578125 \
9.97902e-06 0.0002578125 9.983e-06 0.0002578125 9.98302e-06 0.0007578125 9.987e-06 0.0007578125 9.98702e-06 0.0017578125 9.991e-06 0.0017578125 9.99102e-06 0.0015078125 9.995e-06 0.0015078125 9.99502e-06 0.0032578125 9.999e-06 0.0032578125 9.99902e-06 0.0022578125 1.0003e-05 0.0022578125 \
1.000302e-05 0.0020078125 1.0007e-05 0.0020078125 1.000702e-05 0.0002578125 1.0011e-05 0.0002578125 1.001102e-05 0.0012578125 1.0015e-05 0.0012578125 1.001502e-05 0.0027578125 1.0019e-05 0.0027578125 1.001902e-05 0.0022578125 1.0023e-05 0.0022578125 1.002302e-05 0.0020078125 1.0027e-05 0.0020078125 \
1.002702e-05 0.0002578125 1.0031e-05 0.0002578125 1.003102e-05 0.0007578125 1.0035e-05 0.0007578125 1.003502e-05 0.0012578125 1.0039e-05 0.0012578125 1.003902e-05 0.0017578125 1.0043e-05 0.0017578125 1.004302e-05 0.0032578125 1.0047e-05 0.0032578125 1.004702e-05 0.0027578125 1.0051e-05 0.0027578125 \
1.005102e-05 0.0015078125 1.0055e-05 0.0015078125 1.005502e-05 0.0007578125 1.0059e-05 0.0007578125 1.005902e-05 0.0027578125 1.0063e-05 0.0027578125 1.006302e-05 0.0020078125 1.0067e-05 0.0020078125 1.006702e-05 0.0015078125 1.0071e-05 0.0015078125 1.007102e-05 0.0032578125 1.0075e-05 0.0032578125 \
1.007502e-05 0.0022578125 1.0079e-05 0.0022578125 1.007902e-05 0.0012578125 1.0083e-05 0.0012578125 1.008302e-05 0.0017578125 1.0087e-05 0.0017578125 1.008702e-05 0.0002578125 1.0091e-05 0.0002578125 1.009102e-05 0.0032578125 1.0095e-05 0.0032578125 1.009502e-05 0.0012578125 1.0099e-05 0.0012578125 \
1.009902e-05 0.0002578125 1.0103e-05 0.0002578125 1.010302e-05 0.0022578125 1.0107e-05 0.0022578125 1.010702e-05 0.0017578125 1.0111e-05 0.0017578125 1.011102e-05 0.0015078125 1.0115e-05 0.0015078125 1.011502e-05 0.0007578125 1.0119e-05 0.0007578125 1.011902e-05 0.0020078125 1.0123e-05 0.0020078125 \
1.012302e-05 0.0027578125 1.0127e-05 0.0027578125 1.012702e-05 0.0022578125 1.0131e-05 0.0022578125 1.013102e-05 0.0015078125 1.0135e-05 0.0015078125 1.013502e-05 0.0027578125 1.0139e-05 0.0027578125 1.013902e-05 0.0007578125 1.0143e-05 0.0007578125 1.014302e-05 0.0012578125 1.0147e-05 0.0012578125 \
1.014702e-05 0.0017578125 1.0151e-05 0.0017578125 1.015102e-05 0.0002578125 1.0155e-05 0.0002578125 1.015502e-05 0.0020078125 1.0159e-05 0.0020078125 1.015902e-05 0.0032578125 1.0163e-05 0.0032578125 1.016302e-05 0.0022578125 1.0167e-05 0.0022578125 1.016702e-05 0.0015078125 1.0171e-05 0.0015078125 \
1.017102e-05 0.0012578125 1.0175e-05 0.0012578125 1.017502e-05 0.0027578125 1.0179e-05 0.0027578125 1.017902e-05 0.0032578125 1.0183e-05 0.0032578125 1.018302e-05 0.0020078125 1.0187e-05 0.0020078125 1.018702e-05 0.0007578125 1.0191e-05 0.0007578125 1.019102e-05 0.0002578125 1.0195e-05 0.0002578125 \
1.019502e-05 0.0017578125 1.0199e-05 0.0017578125 1.019902e-05 0.0032578125 1.0203e-05 0.0032578125 1.020302e-05 0.0002578125 1.0207e-05 0.0002578125 1.020702e-05 0.0020078125 1.0211e-05 0.0020078125 1.021102e-05 0.0017578125 1.0215e-05 0.0017578125 1.021502e-05 0.0012578125 1.0219e-05 0.0012578125 \
1.021902e-05 0.0007578125 1.0223e-05 0.0007578125 1.022302e-05 0.0027578125 1.0227e-05 0.0027578125 1.022702e-05 0.0022578125 1.0231e-05 0.0022578125 1.023102e-05 0.0015078125 1.0235e-05 0.0015078125 1.023502e-05 0.0032578125 1.0239e-05 0.0032578125 1.023902e-05 0.0022578125 1.0243e-05 0.0022578125 \
1.024302e-05 0.0002578125 1.0247e-05 0.0002578125 1.024702e-05 0.0012578125 1.0251e-05 0.0012578125 1.025102e-05 0.0017578125 1.0255e-05 0.0017578125 1.025502e-05 0.0015078125 1.0259e-05 0.0015078125 1.025902e-05 0.0007578125 1.0263e-05 0.0007578125 1.026302e-05 0.0020078125 1.0267e-05 0.0020078125 \
1.026702e-05 0.0027578125 1.0271e-05 0.0027578125 1.027102e-05 0.0012578125 1.0275e-05 0.0012578125 1.027502e-05 0.0032578125 1.0279e-05 0.0032578125 1.027902e-05 0.0015078125 1.0283e-05 0.0015078125 1.028302e-05 0.0022578125 1.0287e-05 0.0022578125 1.028702e-05 0.0020078125 1.0291e-05 0.0020078125 \
1.029102e-05 0.0002578125 1.0295e-05 0.0002578125 1.029502e-05 0.0027578125 1.0299e-05 0.0027578125 1.029902e-05 0.0007578125 1.0303e-05 0.0007578125 1.030302e-05 0.0017578125 1.0307e-05 0.0017578125 1.030702e-05 0.0032578125 1.0311e-05 0.0032578125 1.031102e-05 0.0020078125 1.0315e-05 0.0020078125 \
1.031502e-05 0.0027578125 1.0319e-05 0.0027578125 1.031902e-05 0.0017578125 1.0323e-05 0.0017578125 1.032302e-05 0.0002578125 1.0327e-05 0.0002578125 1.032702e-05 0.0022578125 1.0331e-05 0.0022578125 1.033102e-05 0.0015078125 1.0335e-05 0.0015078125 1.033502e-05 0.0007578125 1.0339e-05 0.0007578125 \
1.033902e-05 0.0012578125 1.0343e-05 0.0012578125 1.034302e-05 0.0002578125 1.0347e-05 0.0002578125 1.034702e-05 0.0032578125 1.0351e-05 0.0032578125 1.035102e-05 0.0017578125 1.0355e-05 0.0017578125 1.035502e-05 0.0027578125 1.0359e-05 0.0027578125 1.035902e-05 0.0022578125 1.0363e-05 0.0022578125 \
1.036302e-05 0.0015078125 1.0367e-05 0.0015078125 1.036702e-05 0.0007578125 1.0371e-05 0.0007578125 1.037102e-05 0.0012578125 1.0375e-05 0.0012578125 1.037502e-05 0.0020078125 1.0379e-05 0.0020078125 1.037902e-05 0.0007578125 1.0383e-05 0.0007578125 1.038302e-05 0.0022578125 1.0387e-05 0.0022578125 \
1.038702e-05 0.0002578125 1.0391e-05 0.0002578125 1.039102e-05 0.0015078125 1.0395e-05 0.0015078125 1.039502e-05 0.0012578125 1.0399e-05 0.0012578125 1.039902e-05 0.0017578125 1.0403e-05 0.0017578125 1.040302e-05 0.0032578125 1.0407e-05 0.0032578125 1.040702e-05 0.0027578125 1.0411e-05 0.0027578125 \
1.041102e-05 0.0020078125 1.0415e-05 0.0020078125 1.041502e-05 0.0020078125 1.0419e-05 0.0020078125 1.041902e-05 0.0012578125 1.0423e-05 0.0012578125 1.042302e-05 0.0015078125 1.0427e-05 0.0015078125 1.042702e-05 0.0002578125 1.0431e-05 0.0002578125 1.043102e-05 0.0022578125 1.0435e-05 0.0022578125 \
1.043502e-05 0.0017578125 1.0439e-05 0.0017578125 1.043902e-05 0.0032578125 1.0443e-05 0.0032578125 1.044302e-05 0.0027578125 1.0447e-05 0.0027578125 1.044702e-05 0.0007578125 1.0451e-05 0.0007578125 1.045102e-05 0.0020078125 1.0455e-05 0.0020078125 1.045502e-05 0.0007578125 1.0459e-05 0.0007578125 \
1.045902e-05 0.0017578125 1.0463e-05 0.0017578125 1.046302e-05 0.0015078125 1.0467e-05 0.0015078125 1.046702e-05 0.0027578125 1.0471e-05 0.0027578125 1.047102e-05 0.0012578125 1.0475e-05 0.0012578125 1.047502e-05 0.0002578125 1.0479e-05 0.0002578125 1.047902e-05 0.0022578125 1.0483e-05 0.0022578125 \
1.048302e-05 0.0032578125 1.0487e-05 0.0032578125 1.048702e-05 0.0020078125 1.0491e-05 0.0020078125 1.049102e-05 0.0002578125 1.0495e-05 0.0002578125 1.049502e-05 0.0022578125 1.0499e-05 0.0022578125 1.049902e-05 0.0015078125 1.0503e-05 0.0015078125 1.050302e-05 0.0007578125 1.0507e-05 0.0007578125 \
1.050702e-05 0.0012578125 1.0511e-05 0.0012578125 1.051102e-05 0.0032578125 1.0515e-05 0.0032578125 1.051502e-05 0.0017578125 1.0519e-05 0.0017578125 1.051902e-05 0.0027578125 1.0523e-05 0.0027578125 1.052302e-05 0.0022578125 1.0527e-05 0.0022578125 1.052702e-05 0.0027578125 1.0531e-05 0.0027578125 \
1.053102e-05 0.0015078125 1.0535e-05 0.0015078125 1.053502e-05 0.0020078125 1.0539e-05 0.0020078125 1.053902e-05 0.0002578125 1.0543e-05 0.0002578125 1.054302e-05 0.0007578125 1.0547e-05 0.0007578125 1.054702e-05 0.0017578125 1.0551e-05 0.0017578125 1.055102e-05 0.0032578125 1.0555e-05 0.0032578125 \
1.055502e-05 0.0012578125 1.0559e-05 0.0012578125 1.055902e-05 0.0007578125 1.0563e-05 0.0007578125 1.056302e-05 0.0002578125 1.0567e-05 0.0002578125 1.056702e-05 0.0027578125 1.0571e-05 0.0027578125 1.057102e-05 0.0015078125 1.0575e-05 0.0015078125 1.057502e-05 0.0022578125 1.0579e-05 0.0022578125 \
1.057902e-05 0.0020078125 1.0583e-05 0.0020078125 1.058302e-05 0.0017578125 1.0587e-05 0.0017578125 1.058702e-05 0.0012578125 1.0591e-05 0.0012578125 1.059102e-05 0.0032578125 1.0595e-05 0.0032578125 1.059502e-05 0.0032578125 1.0599e-05 0.0032578125 1.059902e-05 0.0002578125 1.0603e-05 0.0002578125 \
1.060302e-05 0.0017578125 1.0607e-05 0.0017578125 1.060702e-05 0.0007578125 1.0611e-05 0.0007578125 1.061102e-05 0.0015078125 1.0615e-05 0.0015078125 1.061502e-05 0.0012578125 1.0619e-05 0.0012578125 1.061902e-05 0.0020078125 1.0623e-05 0.0020078125 1.062302e-05 0.0027578125 1.0627e-05 0.0027578125 \
1.062702e-05 0.0022578125 1.0631e-05 0.0022578125 1.063102e-05 0.0020078125 1.0635e-05 0.0020078125 1.063502e-05 0.0027578125 1.0639e-05 0.0027578125 1.063902e-05 0.0012578125 1.0643e-05 0.0012578125 1.064302e-05 0.0022578125 1.0647e-05 0.0022578125 1.064702e-05 0.0015078125 1.0651e-05 0.0015078125 \
1.065102e-05 0.0032578125 1.0655e-05 0.0032578125 1.065502e-05 0.0007578125 1.0659e-05 0.0007578125 1.065902e-05 0.0002578125 1.0663e-05 0.0002578125 1.066302e-05 0.0017578125 1.0667e-05 0.0017578125 1.066702e-05 0.0017578125 1.0671e-05 0.0017578125 1.067102e-05 0.0020078125 1.0675e-05 0.0020078125 \
1.067502e-05 0.0022578125 1.0679e-05 0.0022578125 1.067902e-05 0.0012578125 1.0683e-05 0.0012578125 1.068302e-05 0.0002578125 1.0687e-05 0.0002578125 1.068702e-05 0.0015078125 1.0691e-05 0.0015078125 1.069102e-05 0.0027578125 1.0695e-05 0.0027578125 1.069502e-05 0.0032578125 1.0699e-05 0.0032578125 \
1.069902e-05 0.0007578125 1.0703e-05 0.0007578125 1.070302e-05 0.0027578125 1.0707e-05 0.0027578125 1.070702e-05 0.0007578125 1.0711e-05 0.0007578125 1.071102e-05 0.0032578125 1.0715e-05 0.0032578125 1.071502e-05 0.0022578125 1.0719e-05 0.0022578125 1.071902e-05 0.0012578125 1.0723e-05 0.0012578125 \
1.072302e-05 0.0015078125 1.0727e-05 0.0015078125 1.072702e-05 0.0017578125 1.0731e-05 0.0017578125 1.073102e-05 0.0002578125 1.0735e-05 0.0002578125 1.073502e-05 0.0020078125 1.0739e-05 0.0020078125 1.073902e-05 0.0027578125 1.0743e-05 0.0027578125 1.074302e-05 0.0015078125 1.0747e-05 0.0015078125 \
1.074702e-05 0.0020078125 1.0751e-05 0.0020078125 1.075102e-05 0.0032578125 1.0755e-05 0.0032578125 1.075502e-05 0.0002578125 1.0759e-05 0.0002578125 1.075902e-05 0.0007578125 1.0763e-05 0.0007578125 1.076302e-05 0.0022578125 1.0767e-05 0.0022578125 1.076702e-05 0.0012578125 1.0771e-05 0.0012578125 \
1.077102e-05 0.0017578125 1.0775e-05 0.0017578125 1.077502e-05 0.0027578125 1.0779e-05 0.0027578125 1.077902e-05 0.0017578125 1.0783e-05 0.0017578125 1.078302e-05 0.0032578125 1.0787e-05 0.0032578125 1.078702e-05 0.0020078125 1.0791e-05 0.0020078125 1.079102e-05 0.0022578125 1.0795e-05 0.0022578125 \
1.079502e-05 0.0007578125 1.0799e-05 0.0007578125 1.079902e-05 0.0015078125 1.0803e-05 0.0015078125 1.080302e-05 0.0012578125 1.0807e-05 0.0012578125 1.080702e-05 0.0002578125 1.0811e-05 0.0002578125 1.081102e-05 0.0017578125 1.0815e-05 0.0017578125 1.081502e-05 0.0020078125 1.0819e-05 0.0020078125 \
1.081902e-05 0.0002578125 1.0823e-05 0.0002578125 1.082302e-05 0.0032578125 1.0827e-05 0.0032578125 1.082702e-05 0.0012578125 1.0831e-05 0.0012578125 1.083102e-05 0.0022578125 1.0835e-05 0.0022578125 1.083502e-05 0.0015078125 1.0839e-05 0.0015078125 1.083902e-05 0.0027578125 1.0843e-05 0.0027578125 \
1.084302e-05 0.0007578125 1.0847e-05 0.0007578125 1.084702e-05 0.0015078125 1.0851e-05 0.0015078125 1.085102e-05 0.0022578125 1.0855e-05 0.0022578125 1.085502e-05 0.0032578125 1.0859e-05 0.0032578125 1.085902e-05 0.0002578125 1.0863e-05 0.0002578125 1.086302e-05 0.0027578125 1.0867e-05 0.0027578125 \
1.086702e-05 0.0012578125 1.0871e-05 0.0012578125 1.087102e-05 0.0007578125 1.0875e-05 0.0007578125 1.087502e-05 0.0020078125 1.0879e-05 0.0020078125 1.087902e-05 0.0017578125 1.0883e-05 0.0017578125 1.088302e-05 0.0022578125 1.0887e-05 0.0022578125 1.088702e-05 0.0020078125 1.0891e-05 0.0020078125 \
1.089102e-05 0.0015078125 1.0895e-05 0.0015078125 1.089502e-05 0.0012578125 1.0899e-05 0.0012578125 1.089902e-05 0.0032578125 1.0903e-05 0.0032578125 1.090302e-05 0.0017578125 1.0907e-05 0.0017578125 1.090702e-05 0.0007578125 1.0911e-05 0.0007578125 1.091102e-05 0.0027578125 1.0915e-05 0.0027578125 \
1.091502e-05 0.0002578125 1.0919e-05 0.0002578125 1.091902e-05 0.0015078125 1.0923e-05 0.0015078125 1.092302e-05 0.0027578125 1.0927e-05 0.0027578125 1.092702e-05 0.0012578125 1.0931e-05 0.0012578125 1.093102e-05 0.0007578125 1.0935e-05 0.0007578125 1.093502e-05 0.0002578125 1.0939e-05 0.0002578125 \
1.093902e-05 0.0032578125 1.0943e-05 0.0032578125 1.094302e-05 0.0022578125 1.0947e-05 0.0022578125 1.094702e-05 0.0017578125 1.0951e-05 0.0017578125 1.095102e-05 0.0020078125 1.0955e-05 0.0020078125 1.095502e-05 0.0032578125 1.0959e-05 0.0032578125 1.095902e-05 0.0027578125 1.0963e-05 0.0027578125 \
1.096302e-05 0.0020078125 1.0967e-05 0.0020078125 1.096702e-05 0.0022578125 1.0971e-05 0.0022578125 1.097102e-05 0.0017578125 1.0975e-05 0.0017578125 1.097502e-05 0.0015078125 1.0979e-05 0.0015078125 1.097902e-05 0.0007578125 1.0983e-05 0.0007578125 1.098302e-05 0.0012578125 1.0987e-05 0.0012578125 \
1.098702e-05 0.0002578125 1.0991e-05 0.0002578125 1.099102e-05 0.0017578125 1.0995e-05 0.0017578125 1.099502e-05 0.0022578125 1.0999e-05 0.0022578125 1.099902e-05 0.0015078125 1.1003e-05 0.0015078125 1.100302e-05 0.0020078125 1.1007e-05 0.0020078125 1.100702e-05 0.0012578125 1.1011e-05 0.0012578125 \
1.101102e-05 0.0007578125 1.1015e-05 0.0007578125 1.101502e-05 0.0002578125 1.1019e-05 0.0002578125 1.101902e-05 0.0032578125 1.1023e-05 0.0032578125 1.102302e-05 0.0027578125 1.1027e-05 0.0027578125 1.102702e-05 0.0017578125 1.1031e-05 0.0017578125 1.103102e-05 0.0015078125 1.1035e-05 0.0015078125 \
1.103502e-05 0.0007578125 1.1039e-05 0.0007578125 1.103902e-05 0.0022578125 1.1043e-05 0.0022578125 1.104302e-05 0.0002578125 1.1047e-05 0.0002578125 1.104702e-05 0.0012578125 1.1051e-05 0.0012578125 1.105102e-05 0.0027578125 1.1055e-05 0.0027578125 1.105502e-05 0.0020078125 1.1059e-05 0.0020078125 \
1.105902e-05 0.0032578125 1.1063e-05 0.0032578125 1.106302e-05 0.0015078125 1.1067e-05 0.0015078125 1.106702e-05 0.0017578125 1.1071e-05 0.0017578125 1.107102e-05 0.0027578125 1.1075e-05 0.0027578125 1.107502e-05 0.0022578125 1.1079e-05 0.0022578125 1.107902e-05 0.0032578125 1.1083e-05 0.0032578125 \
1.108302e-05 0.0020078125 1.1087e-05 0.0020078125 1.108702e-05 0.0012578125 1.1091e-05 0.0012578125 1.109102e-05 0.0007578125 1.1095e-05 0.0007578125 1.109502e-05 0.0002578125 1.1099e-05 0.0002578125 1.109902e-05 0.0020078125 1.1103e-05 0.0020078125 1.110302e-05 0.0012578125 1.1107e-05 0.0012578125 \
1.110702e-05 0.0007578125 1.1111e-05 0.0007578125 1.111102e-05 0.0017578125 1.1115e-05 0.0017578125 1.111502e-05 0.0002578125 1.1119e-05 0.0002578125 1.111902e-05 0.0032578125 1.1123e-05 0.0032578125 1.112302e-05 0.0015078125 1.1127e-05 0.0015078125 1.112702e-05 0.0027578125 1.1131e-05 0.0027578125 \
1.113102e-05 0.0022578125 1.1135e-05 0.0022578125 1.113502e-05 0.0012578125 1.1139e-05 0.0012578125 1.113902e-05 0.0027578125 1.1143e-05 0.0027578125 1.114302e-05 0.0015078125 1.1147e-05 0.0015078125 1.114702e-05 0.0007578125 1.1151e-05 0.0007578125 1.115102e-05 0.0022578125 1.1155e-05 0.0022578125 \
1.115502e-05 0.0002578125 1.1159e-05 0.0002578125 1.115902e-05 0.0032578125 1.1163e-05 0.0032578125 1.116302e-05 0.0017578125 1.1167e-05 0.0017578125 1.116702e-05 0.0020078125 1.1171e-05 0.0020078125 1.117102e-05 0.0022578125 1.1175e-05 0.0022578125 1.117502e-05 0.0012578125 1.1179e-05 0.0012578125 \
1.117902e-05 0.0002578125 1.1183e-05 0.0002578125 1.118302e-05 0.0007578125 1.1187e-05 0.0007578125 1.118702e-05 0.0015078125 1.1191e-05 0.0015078125 1.119102e-05 0.0020078125 1.1195e-05 0.0020078125 1.119502e-05 0.0017578125 1.1199e-05 0.0017578125 1.119902e-05 0.0027578125 1.1203e-05 0.0027578125 \
1.120302e-05 0.0032578125 1.1207e-05 0.0032578125 1.120702e-05 0.0022578125 1.1211e-05 0.0022578125 1.121102e-05 0.0015078125 1.1215e-05 0.0015078125 1.121502e-05 0.0017578125 1.1219e-05 0.0017578125 1.121902e-05 0.0027578125 1.1223e-05 0.0027578125 1.122302e-05 0.0020078125 1.1227e-05 0.0020078125 \
1.122702e-05 0.0007578125 1.1231e-05 0.0007578125 1.123102e-05 0.0002578125 1.1235e-05 0.0002578125 1.123502e-05 0.0032578125 1.1239e-05 0.0032578125 1.123902e-05 0.0012578125 1.1243e-05 0.0012578125 1.124302e-05 0.0017578125 1.1247e-05 0.0017578125 1.124702e-05 0.0027578125 1.1251e-05 0.0027578125 \
1.125102e-05 0.0032578125 1.1255e-05 0.0032578125 1.125502e-05 0.0002578125 1.1259e-05 0.0002578125 1.125902e-05 0.0015078125 1.1263e-05 0.0015078125 1.126302e-05 0.0020078125 1.1267e-05 0.0020078125 1.126702e-05 0.0022578125 1.1271e-05 0.0022578125 1.127102e-05 0.0012578125 1.1275e-05 0.0012578125 \
1.127502e-05 0.0007578125 1.1279e-05 0.0007578125 1.127902e-05 0.0022578125 1.1283e-05 0.0022578125 1.128302e-05 0.0007578125 1.1287e-05 0.0007578125 1.128702e-05 0.0032578125 1.1291e-05 0.0032578125 1.129102e-05 0.0017578125 1.1295e-05 0.0017578125 1.129502e-05 0.0002578125 1.1299e-05 0.0002578125 \
1.129902e-05 0.0012578125 1.1303e-05 0.0012578125 1.130302e-05 0.0020078125 1.1307e-05 0.0020078125 1.130702e-05 0.0015078125 1.1311e-05 0.0015078125 1.131102e-05 0.0027578125 1.1315e-05 0.0027578125 1.131502e-05 0.0017578125 1.1319e-05 0.0017578125 1.131902e-05 0.0015078125 1.1323e-05 0.0015078125 \
1.132302e-05 0.0002578125 1.1327e-05 0.0002578125 1.132702e-05 0.0022578125 1.1331e-05 0.0022578125 1.133102e-05 0.0027578125 1.1335e-05 0.0027578125 1.133502e-05 0.0012578125 1.1339e-05 0.0012578125 1.133902e-05 0.0032578125 1.1343e-05 0.0032578125 1.134302e-05 0.0020078125 1.1347e-05 0.0020078125 \
1.134702e-05 0.0007578125 1.1351e-05 0.0007578125 1.135102e-05 0.0032578125 1.1355e-05 0.0032578125 1.135502e-05 0.0017578125 1.1359e-05 0.0017578125 1.135902e-05 0.0007578125 1.1363e-05 0.0007578125 1.136302e-05 0.0012578125 1.1367e-05 0.0012578125 1.136702e-05 0.0002578125 1.1371e-05 0.0002578125 \
1.137102e-05 0.0027578125 1.1375e-05 0.0027578125 1.137502e-05 0.0015078125 1.1379e-05 0.0015078125 1.137902e-05 0.0022578125 1.1383e-05 0.0022578125 1.138302e-05 0.0020078125 1.1387e-05 0.0020078125 1.138702e-05 0.0020078125 1.1391e-05 0.0020078125 1.139102e-05 0.0032578125 1.1395e-05 0.0032578125 \
1.139502e-05 0.0022578125 1.1399e-05 0.0022578125 1.139902e-05 0.0007578125 1.1403e-05 0.0007578125 1.140302e-05 0.0027578125 1.1407e-05 0.0027578125 1.140702e-05 0.0002578125 1.1411e-05 0.0002578125 1.141102e-05 0.0012578125 1.1415e-05 0.0012578125 1.141502e-05 0.0015078125 1.1419e-05 0.0015078125 \
1.141902e-05 0.0017578125 1.1423e-05 0.0017578125 1.142302e-05 0.0022578125 1.1427e-05 0.0022578125 1.142702e-05 0.0032578125 1.1431e-05 0.0032578125 1.143102e-05 0.0027578125 1.1435e-05 0.0027578125 1.143502e-05 0.0015078125 1.1439e-05 0.0015078125 1.143902e-05 0.0012578125 1.1443e-05 0.0012578125 \
1.144302e-05 0.0017578125 1.1447e-05 0.0017578125 1.144702e-05 0.0002578125 1.1451e-05 0.0002578125 1.145102e-05 0.0007578125 1.1455e-05 0.0007578125 1.145502e-05 0.0020078125 1.1459e-05 0.0020078125 1.145902e-05 0.0032578125 1.1463e-05 0.0032578125 1.146302e-05 0.0020078125 1.1467e-05 0.0020078125 \
1.146702e-05 0.0012578125 1.1471e-05 0.0012578125 1.147102e-05 0.0002578125 1.1475e-05 0.0002578125 1.147502e-05 0.0007578125 1.1479e-05 0.0007578125 1.147902e-05 0.0017578125 1.1483e-05 0.0017578125 1.148302e-05 0.0015078125 1.1487e-05 0.0015078125 1.148702e-05 0.0022578125 1.1491e-05 0.0022578125 \
1.149102e-05 0.0027578125 1.1495e-05 0.0027578125 1.149502e-05 0.0007578125 1.1499e-05 0.0007578125 1.149902e-05 0.0002578125 1.1503e-05 0.0002578125 1.150302e-05 0.0015078125 1.1507e-05 0.0015078125 1.150702e-05 0.0020078125 1.1511e-05 0.0020078125 1.151102e-05 0.0032578125 1.1515e-05 0.0032578125 \
1.151502e-05 0.0012578125 1.1519e-05 0.0012578125 1.151902e-05 0.0017578125 1.1523e-05 0.0017578125 1.152302e-05 0.0027578125 1.1527e-05 0.0027578125 1.152702e-05 0.0022578125 1.1531e-05 0.0022578125 1.153102e-05 0.0002578125 1.1535e-05 0.0002578125 1.153502e-05 0.0020078125 1.1539e-05 0.0020078125 \
1.153902e-05 0.0017578125 1.1543e-05 0.0017578125 1.154302e-05 0.0032578125 1.1547e-05 0.0032578125 1.154702e-05 0.0012578125 1.1551e-05 0.0012578125 1.155102e-05 0.0015078125 1.1555e-05 0.0015078125 1.155502e-05 0.0007578125 1.1559e-05 0.0007578125 1.155902e-05 0.0027578125 1.1563e-05 0.0027578125 \
1.156302e-05 0.0022578125 1.1567e-05 0.0022578125 1.156702e-05 0.0017578125 1.1571e-05 0.0017578125 1.157102e-05 0.0002578125 1.1575e-05 0.0002578125 1.157502e-05 0.0027578125 1.1579e-05 0.0027578125 1.157902e-05 0.0032578125 1.1583e-05 0.0032578125 1.158302e-05 0.0012578125 1.1587e-05 0.0012578125 \
1.158702e-05 0.0015078125 1.1591e-05 0.0015078125 1.159102e-05 0.0020078125 1.1595e-05 0.0020078125 1.159502e-05 0.0007578125 1.1599e-05 0.0007578125 1.159902e-05 0.0022578125 1.1603e-05 0.0022578125 1.160302e-05 0.0017578125 1.1607e-05 0.0017578125 1.160702e-05 0.0007578125 1.1611e-05 0.0007578125 \
1.161102e-05 0.0032578125 1.1615e-05 0.0032578125 1.161502e-05 0.0022578125 1.1619e-05 0.0022578125 1.161902e-05 0.0027578125 1.1623e-05 0.0027578125 1.162302e-05 0.0020078125 1.1627e-05 0.0020078125 1.162702e-05 0.0015078125 1.1631e-05 0.0015078125 1.163102e-05 0.0002578125 1.1635e-05 0.0002578125 \
1.163502e-05 0.0012578125 1.1639e-05 0.0012578125 1.163902e-05 0.0020078125 1.1643e-05 0.0020078125 1.164302e-05 0.0007578125 1.1647e-05 0.0007578125 1.164702e-05 0.0012578125 1.1651e-05 0.0012578125 1.165102e-05 0.0015078125 1.1655e-05 0.0015078125 1.165502e-05 0.0032578125 1.1659e-05 0.0032578125 \
1.165902e-05 0.0002578125 1.1663e-05 0.0002578125 1.166302e-05 0.0027578125 1.1667e-05 0.0027578125 1.166702e-05 0.0022578125 1.1671e-05 0.0022578125 1.167102e-05 0.0017578125 1.1675e-05 0.0017578125 1.167502e-05 0.0012578125 1.1679e-05 0.0012578125 1.167902e-05 0.0020078125 1.1683e-05 0.0020078125 \
1.168302e-05 0.0017578125 1.1687e-05 0.0017578125 1.168702e-05 0.0032578125 1.1691e-05 0.0032578125 1.169102e-05 0.0002578125 1.1695e-05 0.0002578125 1.169502e-05 0.0022578125 1.1699e-05 0.0022578125 1.169902e-05 0.0015078125 1.1703e-05 0.0015078125 1.170302e-05 0.0007578125 1.1707e-05 0.0007578125 \
1.170702e-05 0.0027578125 1.1711e-05 0.0027578125 1.171102e-05 0.0022578125 1.1715e-05 0.0022578125 1.171502e-05 0.0012578125 1.1719e-05 0.0012578125 1.171902e-05 0.0032578125 1.1723e-05 0.0032578125 1.172302e-05 0.0027578125 1.1727e-05 0.0027578125 1.172702e-05 0.0002578125 1.1731e-05 0.0002578125 \
1.173102e-05 0.0007578125 1.1735e-05 0.0007578125 1.173502e-05 0.0020078125 1.1739e-05 0.0020078125 1.173902e-05 0.0015078125 1.1743e-05 0.0015078125 1.174302e-05 0.0017578125 1.1747e-05 0.0017578125 1.174702e-05 0.0027578125 1.1751e-05 0.0027578125 1.175102e-05 0.0015078125 1.1755e-05 0.0015078125 \
1.175502e-05 0.0002578125 1.1759e-05 0.0002578125 1.175902e-05 0.0017578125 1.1763e-05 0.0017578125 1.176302e-05 0.0007578125 1.1767e-05 0.0007578125 1.176702e-05 0.0032578125 1.1771e-05 0.0032578125 1.177102e-05 0.0012578125 1.1775e-05 0.0012578125 1.177502e-05 0.0022578125 1.1779e-05 0.0022578125 \
1.177902e-05 0.0020078125 1.1783e-05 0.0020078125 1.178302e-05 0.0020078125 1.1787e-05 0.0020078125 1.178702e-05 0.0012578125 1.1791e-05 0.0012578125 1.179102e-05 0.0022578125 1.1795e-05 0.0022578125 1.179502e-05 0.0015078125 1.1799e-05 0.0015078125 1.179902e-05 0.0032578125 1.1803e-05 0.0032578125 \
1.180302e-05 0.0017578125 1.1807e-05 0.0017578125 1.180702e-05 0.0027578125 1.1811e-05 0.0027578125 1.181102e-05 0.0007578125 1.1815e-05 0.0007578125 1.181502e-05 0.0002578125 1.1819e-05 0.0002578125 1.181902e-05 0.0012578125 1.1823e-05 0.0012578125 1.182302e-05 0.0017578125 1.1827e-05 0.0017578125 \
1.182702e-05 0.0022578125 1.1831e-05 0.0022578125 1.183102e-05 0.0027578125 1.1835e-05 0.0027578125 1.183502e-05 0.0015078125 1.1839e-05 0.0015078125 1.183902e-05 0.0002578125 1.1843e-05 0.0002578125 1.184302e-05 0.0007578125 1.1847e-05 0.0007578125 1.184702e-05 0.0020078125 1.1851e-05 0.0020078125 \
1.185102e-05 0.0032578125 1.1855e-05 0.0032578125 1.185502e-05 0.0022578125 1.1859e-05 0.0022578125 1.185902e-05 0.0017578125 1.1863e-05 0.0017578125 1.186302e-05 0.0020078125 1.1867e-05 0.0020078125 1.186702e-05 0.0015078125 1.1871e-05 0.0015078125 1.187102e-05 0.0002578125 1.1875e-05 0.0002578125 \
1.187502e-05 0.0012578125 1.1879e-05 0.0012578125 1.187902e-05 0.0007578125 1.1883e-05 0.0007578125 1.188302e-05 0.0032578125 1.1887e-05 0.0032578125 1.188702e-05 0.0027578125 1.1891e-05 0.0027578125 1.189102e-05 0.0017578125 1.1895e-05 0.0017578125 1.189502e-05 0.0015078125 1.1899e-05 0.0015078125 \
1.189902e-05 0.0002578125 1.1903e-05 0.0002578125 1.190302e-05 0.0020078125 1.1907e-05 0.0020078125 1.190702e-05 0.0012578125 1.1911e-05 0.0012578125 1.191102e-05 0.0007578125 1.1915e-05 0.0007578125 1.191502e-05 0.0022578125 1.1919e-05 0.0022578125 1.191902e-05 0.0027578125 1.1923e-05 0.0027578125 \
1.192302e-05 0.0032578125 1.1927e-05 0.0032578125 1.192702e-05 0.0027578125 1.1931e-05 0.0027578125 1.193102e-05 0.0015078125 1.1935e-05 0.0015078125 1.193502e-05 0.0007578125 1.1939e-05 0.0007578125 1.193902e-05 0.0022578125 1.1943e-05 0.0022578125 1.194302e-05 0.0032578125 1.1947e-05 0.0032578125 \
1.194702e-05 0.0012578125 1.1951e-05 0.0012578125 1.195102e-05 0.0002578125 1.1955e-05 0.0002578125 1.195502e-05 0.0020078125 1.1959e-05 0.0020078125 1.195902e-05 0.0017578125 1.1963e-05 0.0017578125 1.196302e-05 0.0015078125 1.1967e-05 0.0015078125 1.196702e-05 0.0027578125 1.1971e-05 0.0027578125 \
1.197102e-05 0.0022578125 1.1975e-05 0.0022578125 1.197502e-05 0.0032578125 1.1979e-05 0.0032578125 1.197902e-05 0.0020078125 1.1983e-05 0.0020078125 1.198302e-05 0.0007578125 1.1987e-05 0.0007578125 1.198702e-05 0.0002578125 1.1991e-05 0.0002578125 1.199102e-05 0.0012578125 1.1995e-05 0.0012578125 \
1.199502e-05 0.0017578125 1.1999e-05 0.0017578125 1.199902e-05 0.0022578125 1.2003e-05 0.0022578125 1.200302e-05 0.0027578125 1.2007e-05 0.0027578125 1.200702e-05 0.0007578125 1.2011e-05 0.0007578125 1.201102e-05 0.0032578125 1.2015e-05 0.0032578125 1.201502e-05 0.0017578125 1.2019e-05 0.0017578125 \
1.201902e-05 0.0002578125 1.2023e-05 0.0002578125 1.202302e-05 0.0012578125 1.2027e-05 0.0012578125 1.202702e-05 0.0020078125 1.2031e-05 0.0020078125 1.203102e-05 0.0015078125 1.2035e-05 0.0015078125 1.203502e-05 0.0032578125 1.2039e-05 0.0032578125 1.203902e-05 0.0002578125 1.2043e-05 0.0002578125 \
1.204302e-05 0.0012578125 1.2047e-05 0.0012578125 1.204702e-05 0.0015078125 1.2051e-05 0.0015078125 1.205102e-05 0.0022578125 1.2055e-05 0.0022578125 1.205502e-05 0.0017578125 1.2059e-05 0.0017578125 1.205902e-05 0.0027578125 1.2063e-05 0.0027578125 1.206302e-05 0.0007578125 1.2067e-05 0.0007578125 \
1.206702e-05 0.0020078125 1.2071e-05 0.0020078125 1.207102e-05 0.0007578125 1.2075e-05 0.0007578125 1.207502e-05 0.0002578125 1.2079e-05 0.0002578125 1.207902e-05 0.0020078125 1.2083e-05 0.0020078125 1.208302e-05 0.0027578125 1.2087e-05 0.0027578125 1.208702e-05 0.0032578125 1.2091e-05 0.0032578125 \
1.209102e-05 0.0022578125 1.2095e-05 0.0022578125 1.209502e-05 0.0012578125 1.2099e-05 0.0012578125 1.209902e-05 0.0017578125 1.2103e-05 0.0017578125 1.210302e-05 0.0015078125 1.2107e-05 0.0015078125 1.210702e-05 0.0012578125 1.2111e-05 0.0012578125 1.211102e-05 0.0027578125 1.2115e-05 0.0027578125 \
1.211502e-05 0.0007578125 1.2119e-05 0.0007578125 1.211902e-05 0.0002578125 1.2123e-05 0.0002578125 1.212302e-05 0.0032578125 1.2127e-05 0.0032578125 1.212702e-05 0.0022578125 1.2131e-05 0.0022578125 1.213102e-05 0.0015078125 1.2135e-05 0.0015078125 1.213502e-05 0.0020078125 1.2139e-05 0.0020078125 \
1.213902e-05 0.0017578125 1.2143e-05 0.0017578125 1.214302e-05 0.0027578125 1.2147e-05 0.0027578125 1.214702e-05 0.0002578125 1.2151e-05 0.0002578125 1.215102e-05 0.0022578125 1.2155e-05 0.0022578125 1.215502e-05 0.0017578125 1.2159e-05 0.0017578125 1.215902e-05 0.0012578125 1.2163e-05 0.0012578125 \
1.216302e-05 0.0032578125 1.2167e-05 0.0032578125 1.216702e-05 0.0015078125 1.2171e-05 0.0015078125 1.217102e-05 0.0007578125 1.2175e-05 0.0007578125 1.217502e-05 0.0020078125 1.2179e-05 0.0020078125 1.217902e-05 0.0017578125 1.2183e-05 0.0017578125 1.218302e-05 0.0032578125 1.2187e-05 0.0032578125 \
1.218702e-05 0.0007578125 1.2191e-05 0.0007578125 1.219102e-05 0.0015078125 1.2195e-05 0.0015078125 1.219502e-05 0.0027578125 1.2199e-05 0.0027578125 1.219902e-05 0.0002578125 1.2203e-05 0.0002578125 1.220302e-05 0.0012578125 1.2207e-05 0.0012578125 1.220702e-05 0.0020078125 1.2211e-05 0.0020078125 \
1.221102e-05 0.0022578125 1.2215e-05 0.0022578125 1.221502e-05 0.0027578125 1.2219e-05 0.0027578125 1.221902e-05 0.0017578125 1.2223e-05 0.0017578125 1.222302e-05 0.0020078125 1.2227e-05 0.0020078125 1.222702e-05 0.0015078125 1.2231e-05 0.0015078125 1.223102e-05 0.0032578125 1.2235e-05 0.0032578125 \
1.223502e-05 0.0012578125 1.2239e-05 0.0012578125 1.223902e-05 0.0022578125 1.2243e-05 0.0022578125 1.224302e-05 0.0002578125 1.2247e-05 0.0002578125 1.224702e-05 0.0007578125 1.2251e-05 0.0007578125 1.225102e-05 0.0017578125 1.2255e-05 0.0017578125 1.225502e-05 0.0015078125 1.2259e-05 0.0015078125 \
1.225902e-05 0.0027578125 1.2263e-05 0.0027578125 1.226302e-05 0.0022578125 1.2267e-05 0.0022578125 1.226702e-05 0.0020078125 1.2271e-05 0.0020078125 1.227102e-05 0.0032578125 1.2275e-05 0.0032578125 1.227502e-05 0.0012578125 1.2279e-05 0.0012578125 1.227902e-05 0.0007578125 1.2283e-05 0.0007578125 \
1.228302e-05 0.0002578125 1.2287e-05 0.0002578125 1.228702e-05 0.0027578125 1.2291e-05 0.0027578125 1.229102e-05 0.0022578125 1.2295e-05 0.0022578125 1.229502e-05 0.0002578125 1.2299e-05 0.0002578125 1.229902e-05 0.0017578125 1.2303e-05 0.0017578125 1.230302e-05 0.0020078125 1.2307e-05 0.0020078125 \
1.230702e-05 0.0015078125 1.2311e-05 0.0015078125 1.231102e-05 0.0012578125 1.2315e-05 0.0012578125 1.231502e-05 0.0007578125 1.2319e-05 0.0007578125 1.231902e-05 0.0032578125 1.2323e-05 0.0032578125 1.232302e-05 0.0007578125 1.2327e-05 0.0007578125 1.232702e-05 0.0012578125 1.2331e-05 0.0012578125 \
1.233102e-05 0.0002578125 1.2335e-05 0.0002578125 1.233502e-05 0.0017578125 1.2339e-05 0.0017578125 1.233902e-05 0.0032578125 1.2343e-05 0.0032578125 1.234302e-05 0.0027578125 1.2347e-05 0.0027578125 1.234702e-05 0.0020078125 1.2351e-05 0.0020078125 1.235102e-05 0.0022578125 1.2355e-05 0.0022578125 \
1.235502e-05 0.0015078125 1.2359e-05 0.0015078125 1.235902e-05 0.0002578125 1.2363e-05 0.0002578125 1.236302e-05 0.0017578125 1.2367e-05 0.0017578125 1.236702e-05 0.0032578125 1.2371e-05 0.0032578125 1.237102e-05 0.0020078125 1.2375e-05 0.0020078125 1.237502e-05 0.0012578125 1.2379e-05 0.0012578125 \
1.237902e-05 0.0027578125 1.2383e-05 0.0027578125 1.238302e-05 0.0022578125 1.2387e-05 0.0022578125 1.238702e-05 0.0007578125 1.2391e-05 0.0007578125 1.239102e-05 0.0015078125 1.2395e-05 0.0015078125 1.239502e-05 0.0015078125 1.2399e-05 0.0015078125 1.239902e-05 0.0007578125 1.2403e-05 0.0007578125 \
1.240302e-05 0.0012578125 1.2407e-05 0.0012578125 1.240702e-05 0.0027578125 1.2411e-05 0.0027578125 1.241102e-05 0.0002578125 1.2415e-05 0.0002578125 1.241502e-05 0.0022578125 1.2419e-05 0.0022578125 1.241902e-05 0.0032578125 1.2423e-05 0.0032578125 1.242302e-05 0.0020078125 1.2427e-05 0.0020078125 \
1.242702e-05 0.0017578125 1.2431e-05 0.0017578125 1.243102e-05 0.0002578125 1.2435e-05 0.0002578125 1.243502e-05 0.0022578125 1.2439e-05 0.0022578125 1.243902e-05 0.0032578125 1.2443e-05 0.0032578125 1.244302e-05 0.0007578125 1.2447e-05 0.0007578125 1.244702e-05 0.0012578125 1.2451e-05 0.0012578125 \
1.245102e-05 0.0015078125 1.2455e-05 0.0015078125 1.245502e-05 0.0017578125 1.2459e-05 0.0017578125 1.245902e-05 0.0027578125 1.2463e-05 0.0027578125 1.246302e-05 0.0020078125 1.2467e-05 0.0020078125 1.246702e-05 0.0002578125 1.2471e-05 0.0002578125 1.247102e-05 0.0032578125 1.2475e-05 0.0032578125 \
1.247502e-05 0.0012578125 1.2479e-05 0.0012578125 1.247902e-05 0.0020078125 1.2483e-05 0.0020078125 1.248302e-05 0.0027578125 1.2487e-05 0.0027578125 1.248702e-05 0.0017578125 1.2491e-05 0.0017578125 1.249102e-05 0.0022578125 1.2495e-05 0.0022578125 1.249502e-05 0.0007578125 1.2499e-05 0.0007578125 \
1.249902e-05 0.0015078125 1.2503e-05 0.0015078125 1.250302e-05 0.0022578125 1.2507e-05 0.0022578125 1.250702e-05 0.0007578125 1.2511e-05 0.0007578125 1.251102e-05 0.0027578125 1.2515e-05 0.0027578125 1.251502e-05 0.0002578125 1.2519e-05 0.0002578125 1.251902e-05 0.0032578125 1.2523e-05 0.0032578125 \
1.252302e-05 0.0020078125 1.2527e-05 0.0020078125 1.252702e-05 0.0012578125 1.2531e-05 0.0012578125 1.253102e-05 0.0017578125 1.2535e-05 0.0017578125 1.253502e-05 0.0015078125 1.2539e-05 0.0015078125 1.253902e-05 0.0002578125 1.2543e-05 0.0002578125 1.254302e-05 0.0015078125 1.2547e-05 0.0015078125 \
1.254702e-05 0.0022578125 1.2551e-05 0.0022578125 1.255102e-05 0.0012578125 1.2555e-05 0.0012578125 1.255502e-05 0.0017578125 1.2559e-05 0.0017578125 1.255902e-05 0.0007578125 1.2563e-05 0.0007578125 1.256302e-05 0.0020078125 1.2567e-05 0.0020078125 1.256702e-05 0.0027578125 1.2571e-05 0.0027578125 \
1.257102e-05 0.0032578125 1.2575e-05 0.0032578125 1.257502e-05 0.0007578125 1.2579e-05 0.0007578125 1.257902e-05 0.0027578125 1.2583e-05 0.0027578125 1.258302e-05 0.0012578125 1.2587e-05 0.0012578125 1.258702e-05 0.0015078125 1.2591e-05 0.0015078125 1.259102e-05 0.0017578125 1.2595e-05 0.0017578125 \
1.259502e-05 0.0022578125 1.2599e-05 0.0022578125 1.259902e-05 0.0020078125 1.2603e-05 0.0020078125 1.260302e-05 0.0032578125 1.2607e-05 0.0032578125 1.260702e-05 0.0002578125 1.2611e-05 0.0002578125 1.261102e-05 0.0017578125 1.2615e-05 0.0017578125 1.261502e-05 0.0007578125 1.2619e-05 0.0007578125 \
1.261902e-05 0.0012578125 1.2623e-05 0.0012578125 1.262302e-05 0.0002578125 1.2627e-05 0.0002578125 1.262702e-05 0.0022578125 1.2631e-05 0.0022578125 1.263102e-05 0.0032578125 1.2635e-05 0.0032578125 1.263502e-05 0.0027578125 1.2639e-05 0.0027578125 1.263902e-05 0.0020078125 1.2643e-05 0.0020078125 \
1.264302e-05 0.0015078125 1.2647e-05 0.0015078125 1.264702e-05 0.0017578125 1.2651e-05 0.0017578125 1.265102e-05 0.0002578125 1.2655e-05 0.0002578125 1.265502e-05 0.0012578125 1.2659e-05 0.0012578125 1.265902e-05 0.0022578125 1.2663e-05 0.0022578125 1.266302e-05 0.0027578125 1.2667e-05 0.0027578125 \
1.266702e-05 0.0007578125 1.2671e-05 0.0007578125 1.267102e-05 0.0032578125 1.2675e-05 0.0032578125 1.267502e-05 0.0015078125 1.2679e-05 0.0015078125 1.267902e-05 0.0020078125 1.2683e-05 0.0020078125 1.268302e-05 0.0032578125 1.2687e-05 0.0032578125 1.268702e-05 0.0015078125 1.2691e-05 0.0015078125 \
1.269102e-05 0.0020078125 1.2695e-05 0.0020078125 1.269502e-05 0.0022578125 1.2699e-05 0.0022578125 1.269902e-05 0.0017578125 1.2703e-05 0.0017578125 1.270302e-05 0.0002578125 1.2707e-05 0.0002578125 1.270702e-05 0.0027578125 1.2711e-05 0.0027578125 1.271102e-05 0.0007578125 1.2715e-05 0.0007578125 \
1.271502e-05 0.0012578125 1.2719e-05 0.0012578125 1.271902e-05 0.0015078125 1.2723e-05 0.0015078125 1.272302e-05 0.0012578125 1.2727e-05 0.0012578125 1.272702e-05 0.0022578125 1.2731e-05 0.0022578125 1.273102e-05 0.0027578125 1.2735e-05 0.0027578125 1.273502e-05 0.0032578125 1.2739e-05 0.0032578125 \
1.273902e-05 0.0002578125 1.2743e-05 0.0002578125 1.274302e-05 0.0017578125 1.2747e-05 0.0017578125 1.274702e-05 0.0020078125 1.2751e-05 0.0020078125 1.275102e-05 0.0007578125 1.2755e-05 0.0007578125 1.275502e-05 0.0032578125 1.2759e-05 0.0032578125 1.275902e-05 0.0020078125 1.2763e-05 0.0020078125 \
1.276302e-05 0.0012578125 1.2767e-05 0.0012578125 1.276702e-05 0.0022578125 1.2771e-05 0.0022578125 1.277102e-05 0.0015078125 1.2775e-05 0.0015078125 1.277502e-05 0.0017578125 1.2779e-05 0.0017578125 1.277902e-05 0.0007578125 1.2783e-05 0.0007578125 1.278302e-05 0.0002578125 1.2787e-05 0.0002578125 \
1.278702e-05 0.0027578125 1.2791e-05 0.0027578125 1.279102e-05 0.0007578125 1.2795e-05 0.0007578125 1.279502e-05 0.0002578125 1.2799e-05 0.0002578125 1.279902e-05 0.0012578125 1.2803e-05 0.0012578125 1.280302e-05 0.0032578125 1.2807e-05 0.0032578125 1.280702e-05 0.0022578125 1.2811e-05 0.0022578125 \
1.281102e-05 0.0017578125 1.2815e-05 0.0017578125 1.281502e-05 0.0015078125 1.2819e-05 0.0015078125 1.281902e-05 0.0020078125 1.2823e-05 0.0020078125 1.282302e-05 0.0027578125 1.2827e-05 0.0027578125 1.282702e-05 0.0017578125 1.2831e-05 0.0017578125 1.283102e-05 0.0027578125 1.2835e-05 0.0027578125 \
1.283502e-05 0.0012578125 1.2839e-05 0.0012578125 1.283902e-05 0.0015078125 1.2843e-05 0.0015078125 1.284302e-05 0.0032578125 1.2847e-05 0.0032578125 1.284702e-05 0.0007578125 1.2851e-05 0.0007578125 1.285102e-05 0.0002578125 1.2855e-05 0.0002578125 1.285502e-05 0.0022578125 1.2859e-05 0.0022578125 \
1.285902e-05 0.0020078125 1.2863e-05 0.0020078125 1.286302e-05 0.0002578125 1.2867e-05 0.0002578125 1.286702e-05 0.0015078125 1.2871e-05 0.0015078125 1.287102e-05 0.0020078125 1.2875e-05 0.0020078125 1.287502e-05 0.0032578125 1.2879e-05 0.0032578125 1.287902e-05 0.0022578125 1.2883e-05 0.0022578125 \
1.288302e-05 0.0012578125 1.2887e-05 0.0012578125 1.288702e-05 0.0017578125 1.2891e-05 0.0017578125 1.289102e-05 0.0007578125 1.2895e-05 0.0007578125 1.289502e-05 0.0027578125 1.2899e-05 0.0027578125 1.289902e-05 0.0015078125 1.2903e-05 0.0015078125 1.290302e-05 0.0017578125 1.2907e-05 0.0017578125 \
1.290702e-05 0.0007578125 1.2911e-05 0.0007578125 1.291102e-05 0.0012578125 1.2915e-05 0.0012578125 1.291502e-05 0.0022578125 1.2919e-05 0.0022578125 1.291902e-05 0.0027578125 1.2923e-05 0.0027578125 1.292302e-05 0.0002578125 1.2927e-05 0.0002578125 1.292702e-05 0.0032578125 1.2931e-05 0.0032578125 \
1.293102e-05 0.0020078125 1.2935e-05 0.0020078125 1.293502e-05 0.0020078125 1.2939e-05 0.0020078125 1.293902e-05 0.0022578125 1.2943e-05 0.0022578125 1.294302e-05 0.0007578125 1.2947e-05 0.0007578125 1.294702e-05 0.0032578125 1.2951e-05 0.0032578125 1.295102e-05 0.0015078125 1.2955e-05 0.0015078125 \
1.295502e-05 0.0027578125 1.2959e-05 0.0027578125 1.295902e-05 0.0017578125 1.2963e-05 0.0017578125 1.296302e-05 0.0002578125 1.2967e-05 0.0002578125 1.296702e-05 0.0012578125 1.2971e-05 0.0012578125 1.297102e-05 0.0007578125 1.2975e-05 0.0007578125 1.297502e-05 0.0020078125 1.2979e-05 0.0020078125 \
1.297902e-05 0.0032578125 1.2983e-05 0.0032578125 1.298302e-05 0.0015078125 1.2987e-05 0.0015078125 1.298702e-05 0.0027578125 1.2991e-05 0.0027578125 1.299102e-05 0.0002578125 1.2995e-05 0.0002578125 1.299502e-05 0.0012578125 1.2999e-05 0.0012578125 1.299902e-05 0.0017578125 1.3003e-05 0.0017578125 \
1.300302e-05 0.0022578125 1.3007e-05 0.0022578125 1.300702e-05 0.0007578125 1.3011e-05 0.0007578125 1.301102e-05 0.0015078125 1.3015e-05 0.0015078125 1.301502e-05 0.0032578125 1.3019e-05 0.0032578125 1.301902e-05 0.0027578125 1.3023e-05 0.0027578125 1.302302e-05 0.0022578125 1.3027e-05 0.0022578125 \
1.302702e-05 0.0017578125 1.3031e-05 0.0017578125 1.303102e-05 0.0020078125 1.3035e-05 0.0020078125 1.303502e-05 0.0002578125 1.3039e-05 0.0002578125 1.303902e-05 0.0012578125 1.3043e-05 0.0012578125 1.304302e-05 0.0012578125 1.3047e-05 0.0012578125 1.304702e-05 0.0020078125 1.3051e-05 0.0020078125 \
1.305102e-05 0.0015078125 1.3055e-05 0.0015078125 1.305502e-05 0.0027578125 1.3059e-05 0.0027578125 1.305902e-05 0.0007578125 1.3063e-05 0.0007578125 1.306302e-05 0.0002578125 1.3067e-05 0.0002578125 1.306702e-05 0.0017578125 1.3071e-05 0.0017578125 1.307102e-05 0.0022578125 1.3075e-05 0.0022578125 \
1.307502e-05 0.0032578125 1.3079e-05 0.0032578125 1.307902e-05 0.0015078125 1.3083e-05 0.0015078125 1.308302e-05 0.0020078125 1.3087e-05 0.0020078125 1.308702e-05 0.0022578125 1.3091e-05 0.0022578125 1.309102e-05 0.0032578125 1.3095e-05 0.0032578125 1.309502e-05 0.0007578125 1.3099e-05 0.0007578125 \
1.309902e-05 0.0002578125 1.3103e-05 0.0002578125 1.310302e-05 0.0017578125 1.3107e-05 0.0017578125 1.310702e-05 0.0012578125 1.3111e-05 0.0012578125 1.311102e-05 0.0027578125 1.3115e-05 0.0027578125 1.311502e-05 0.0017578125 1.3119e-05 0.0017578125 1.311902e-05 0.0002578125 1.3123e-05 0.0002578125 \
1.312302e-05 0.0015078125 1.3127e-05 0.0015078125 1.312702e-05 0.0012578125 1.3131e-05 0.0012578125 1.313102e-05 0.0007578125 1.3135e-05 0.0007578125 1.313502e-05 0.0027578125 1.3139e-05 0.0027578125 1.313902e-05 0.0032578125 1.3143e-05 0.0032578125 1.314302e-05 0.0020078125 1.3147e-05 0.0020078125 \
1.314702e-05 0.0022578125 1.3151e-05 0.0022578125 1.315102e-05 0.0002578125 1.3155e-05 0.0002578125 1.315502e-05 0.0015078125 1.3159e-05 0.0015078125 1.315902e-05 0.0017578125 1.3163e-05 0.0017578125 1.316302e-05 0.0032578125 1.3167e-05 0.0032578125 1.316702e-05 0.0027578125 1.3171e-05 0.0027578125 \
1.317102e-05 0.0020078125 1.3175e-05 0.0020078125 1.317502e-05 0.0022578125 1.3179e-05 0.0022578125 1.317902e-05 0.0007578125 1.3183e-05 0.0007578125 1.318302e-05 0.0012578125 1.3187e-05 0.0012578125 1.318702e-05 0.0020078125 1.3191e-05 0.0020078125 1.319102e-05 0.0032578125 1.3195e-05 0.0032578125 \
1.319502e-05 0.0022578125 1.3199e-05 0.0022578125 1.319902e-05 0.0015078125 1.3203e-05 0.0015078125 1.320302e-05 0.0002578125 1.3207e-05 0.0002578125 1.320702e-05 0.0012578125 1.3211e-05 0.0012578125 1.321102e-05 0.0027578125 1.3215e-05 0.0027578125 1.321502e-05 0.0007578125 1.3219e-05 0.0007578125 \
1.321902e-05 0.0017578125 1.3223e-05 0.0017578125 1.322302e-05 0.0015078125 1.3227e-05 0.0015078125 1.322702e-05 0.0032578125 1.3231e-05 0.0032578125 1.323102e-05 0.0027578125 1.3235e-05 0.0027578125 1.323502e-05 0.0002578125 1.3239e-05 0.0002578125 1.323902e-05 0.0012578125 1.3243e-05 0.0012578125 \
1.324302e-05 0.0007578125 1.3247e-05 0.0007578125 1.324702e-05 0.0017578125 1.3251e-05 0.0017578125 1.325102e-05 0.0022578125 1.3255e-05 0.0022578125 1.325502e-05 0.0020078125 1.3259e-05 0.0020078125 1.325902e-05 0.0017578125 1.3263e-05 0.0017578125 1.326302e-05 0.0015078125 1.3267e-05 0.0015078125 \
1.326702e-05 0.0007578125 1.3271e-05 0.0007578125 1.327102e-05 0.0002578125 1.3275e-05 0.0002578125 1.327502e-05 0.0020078125 1.3279e-05 0.0020078125 1.327902e-05 0.0032578125 1.3283e-05 0.0032578125 1.328302e-05 0.0012578125 1.3287e-05 0.0012578125 1.328702e-05 0.0027578125 1.3291e-05 0.0027578125 \
1.329102e-05 0.0022578125 1.3295e-05 0.0022578125 1.329502e-05 0.0017578125 1.3299e-05 0.0017578125 1.329902e-05 0.0002578125 1.3303e-05 0.0002578125 1.330302e-05 0.0012578125 1.3307e-05 0.0012578125 1.330702e-05 0.0007578125 1.3311e-05 0.0007578125 1.331102e-05 0.0020078125 1.3315e-05 0.0020078125 \
1.331502e-05 0.0032578125 1.3319e-05 0.0032578125 1.331902e-05 0.0027578125 1.3323e-05 0.0027578125 1.332302e-05 0.0022578125 1.3327e-05 0.0022578125 1.332702e-05 0.0015078125 1.3331e-05 0.0015078125 1.333102e-05 0.0027578125 1.3335e-05 0.0027578125 1.333502e-05 0.0015078125 1.3339e-05 0.0015078125 \
1.333902e-05 0.0012578125 1.3343e-05 0.0012578125 1.334302e-05 0.0022578125 1.3347e-05 0.0022578125 1.334702e-05 0.0002578125 1.3351e-05 0.0002578125 1.335102e-05 0.0020078125 1.3355e-05 0.0020078125 1.335502e-05 0.0017578125 1.3359e-05 0.0017578125 1.335902e-05 0.0032578125 1.3363e-05 0.0032578125 \
1.336302e-05 0.0007578125 1.3367e-05 0.0007578125 1.336702e-05 0.0020078125 1.3371e-05 0.0020078125 1.337102e-05 0.0015078125 1.3375e-05 0.0015078125 1.337502e-05 0.0012578125 1.3379e-05 0.0012578125 1.337902e-05 0.0022578125 1.3383e-05 0.0022578125 1.338302e-05 0.0032578125 1.3387e-05 0.0032578125 \
1.338702e-05 0.0007578125 1.3391e-05 0.0007578125 1.339102e-05 0.0027578125 1.3395e-05 0.0027578125 1.339502e-05 0.0017578125 1.3399e-05 0.0017578125 1.339902e-05 0.0002578125 1.3403e-05 0.0002578125 1.340302e-05 0.0022578125 1.3407e-05 0.0022578125 1.340702e-05 0.0027578125 1.3411e-05 0.0027578125 \
1.341102e-05 0.0007578125 1.3415e-05 0.0007578125 1.341502e-05 0.0012578125 1.3419e-05 0.0012578125 1.341902e-05 0.0020078125 1.3423e-05 0.0020078125 1.342302e-05 0.0032578125 1.3427e-05 0.0032578125 1.342702e-05 0.0002578125 1.3431e-05 0.0002578125 1.343102e-05 0.0017578125 1.3435e-05 0.0017578125 \
1.343502e-05 0.0015078125 1.3439e-05 0.0015078125 1.343902e-05 0.0007578125 1.3443e-05 0.0007578125 1.344302e-05 0.0020078125 1.3447e-05 0.0020078125 1.344702e-05 0.0012578125 1.3451e-05 0.0012578125 1.345102e-05 0.0017578125 1.3455e-05 0.0017578125 1.345502e-05 0.0022578125 1.3459e-05 0.0022578125 \
1.345902e-05 0.0032578125 1.3463e-05 0.0032578125 1.346302e-05 0.0002578125 1.3467e-05 0.0002578125 1.346702e-05 0.0027578125 1.3471e-05 0.0027578125 1.347102e-05 0.0015078125 1.3475e-05 0.0015078125 1.347502e-05 0.0020078125 1.3479e-05 0.0020078125 1.347902e-05 0.0017578125 1.3483e-05 0.0017578125 \
1.348302e-05 0.0032578125 1.3487e-05 0.0032578125 1.348702e-05 0.0007578125 1.3491e-05 0.0007578125 1.349102e-05 0.0012578125 1.3495e-05 0.0012578125 1.349502e-05 0.0002578125 1.3499e-05 0.0002578125 1.349902e-05 0.0015078125 1.3503e-05 0.0015078125 1.350302e-05 0.0027578125 1.3507e-05 0.0027578125 \
1.350702e-05 0.0022578125 1.3511e-05 0.0022578125 1.351102e-05 0.0015078125 1.3515e-05 0.0015078125 1.351502e-05 0.0012578125 1.3519e-05 0.0012578125 1.351902e-05 0.0020078125 1.3523e-05 0.0020078125 1.352302e-05 0.0017578125 1.3527e-05 0.0017578125 1.352702e-05 0.0027578125 1.3531e-05 0.0027578125 \
1.353102e-05 0.0022578125 1.3535e-05 0.0022578125 1.353502e-05 0.0007578125 1.3539e-05 0.0007578125 1.353902e-05 0.0032578125 1.3543e-05 0.0032578125 1.354302e-05 0.0002578125 1.3547e-05 0.0002578125 1.354702e-05 0.0032578125 1.3551e-05 0.0032578125 1.355102e-05 0.0017578125 1.3555e-05 0.0017578125 \
1.355502e-05 0.0007578125 1.3559e-05 0.0007578125 1.355902e-05 0.0027578125 1.3563e-05 0.0027578125 1.356302e-05 0.0015078125 1.3567e-05 0.0015078125 1.356702e-05 0.0002578125 1.3571e-05 0.0002578125 1.357102e-05 0.0020078125 1.3575e-05 0.0020078125 1.357502e-05 0.0012578125 1.3579e-05 0.0012578125 \
1.357902e-05 0.0022578125 1.3583e-05 0.0022578125 1.358302e-05 0.0032578125 1.3587e-05 0.0032578125 1.358702e-05 0.0027578125 1.3591e-05 0.0027578125 1.359102e-05 0.0012578125 1.3595e-05 0.0012578125 1.359502e-05 0.0007578125 1.3599e-05 0.0007578125 1.359902e-05 0.0015078125 1.3603e-05 0.0015078125 \
1.360302e-05 0.0002578125 1.3607e-05 0.0002578125 1.360702e-05 0.0022578125 1.3611e-05 0.0022578125 1.361102e-05 0.0017578125 1.3615e-05 0.0017578125 1.361502e-05 0.0020078125 1.3619e-05 0.0020078125 1.361902e-05 0.0027578125 1.3623e-05 0.0027578125 1.362302e-05 0.0002578125 1.3627e-05 0.0002578125 \
1.362702e-05 0.0007578125 1.3631e-05 0.0007578125 1.363102e-05 0.0017578125 1.3635e-05 0.0017578125 1.363502e-05 0.0022578125 1.3639e-05 0.0022578125 1.363902e-05 0.0020078125 1.3643e-05 0.0020078125 1.364302e-05 0.0012578125 1.3647e-05 0.0012578125 1.364702e-05 0.0032578125 1.3651e-05 0.0032578125 \
1.365102e-05 0.0015078125 1.3655e-05 0.0015078125 1.365502e-05 0.0017578125 1.3659e-05 0.0017578125 1.365902e-05 0.0012578125 1.3663e-05 0.0012578125 1.366302e-05 0.0002578125 1.3667e-05 0.0002578125 1.366702e-05 0.0007578125 1.3671e-05 0.0007578125 1.367102e-05 0.0027578125 1.3675e-05 0.0027578125 \
1.367502e-05 0.0032578125 1.3679e-05 0.0032578125 1.367902e-05 0.0020078125 1.3683e-05 0.0020078125 1.368302e-05 0.0015078125 1.3687e-05 0.0015078125 1.368702e-05 0.0022578125 1.3691e-05 0.0022578125 1.369102e-05 0.0020078125 1.3695e-05 0.0020078125 1.369502e-05 0.0002578125 1.3699e-05 0.0002578125 \
1.369902e-05 0.0032578125 1.3703e-05 0.0032578125 1.370302e-05 0.0007578125 1.3707e-05 0.0007578125 1.370702e-05 0.0027578125 1.3711e-05 0.0027578125 1.371102e-05 0.0012578125 1.3715e-05 0.0012578125 1.371502e-05 0.0017578125 1.3719e-05 0.0017578125 1.371902e-05 0.0015078125 1.3723e-05 0.0015078125 \
1.372302e-05 0.0022578125 1.3727e-05 0.0022578125 1.372702e-05 0.0022578125 1.3731e-05 0.0022578125 1.373102e-05 0.0012578125 1.3735e-05 0.0012578125 1.373502e-05 0.0032578125 1.3739e-05 0.0032578125 1.373902e-05 0.0002578125 1.3743e-05 0.0002578125 1.374302e-05 0.0007578125 1.3747e-05 0.0007578125 \
1.374702e-05 0.0020078125 1.3751e-05 0.0020078125 1.375102e-05 0.0027578125 1.3755e-05 0.0027578125 1.375502e-05 0.0015078125 1.3759e-05 0.0015078125 1.375902e-05 0.0017578125 1.3763e-05 0.0017578125 1.376302e-05 0.0027578125 1.3767e-05 0.0027578125 1.376702e-05 0.0007578125 1.3771e-05 0.0007578125 \
1.377102e-05 0.0002578125 1.3775e-05 0.0002578125 1.377502e-05 0.0032578125 1.3779e-05 0.0032578125 1.377902e-05 0.0015078125 1.3783e-05 0.0015078125 1.378302e-05 0.0017578125 1.3787e-05 0.0017578125 1.378702e-05 0.0020078125 1.3791e-05 0.0020078125 1.379102e-05 0.0012578125 1.3795e-05 0.0012578125 \
1.379502e-05 0.0022578125 1.3799e-05 0.0022578125 1.379902e-05 0.0002578125 1.3803e-05 0.0002578125 1.380302e-05 0.0027578125 1.3807e-05 0.0027578125 1.380702e-05 0.0032578125 1.3811e-05 0.0032578125 1.381102e-05 0.0022578125 1.3815e-05 0.0022578125 1.381502e-05 0.0007578125 1.3819e-05 0.0007578125 \
1.381902e-05 0.0020078125 1.3823e-05 0.0020078125 1.382302e-05 0.0017578125 1.3827e-05 0.0017578125 1.382702e-05 0.0012578125 1.3831e-05 0.0012578125 1.383102e-05 0.0015078125 1.3835e-05 0.0015078125 1.383502e-05 0.0002578125 1.3839e-05 0.0002578125 1.383902e-05 0.0007578125 1.3843e-05 0.0007578125 \
1.384302e-05 0.0020078125 1.3847e-05 0.0020078125 1.384702e-05 0.0012578125 1.3851e-05 0.0012578125 1.385102e-05 0.0027578125 1.3855e-05 0.0027578125 1.385502e-05 0.0032578125 1.3859e-05 0.0032578125 1.385902e-05 0.0017578125 1.3863e-05 0.0017578125 1.386302e-05 0.0015078125 1.3867e-05 0.0015078125 \
1.386702e-05 0.0022578125 1.3871e-05 0.0022578125 1.387102e-05 0.0032578125 1.3875e-05 0.0032578125 1.387502e-05 0.0017578125 1.3879e-05 0.0017578125 1.387902e-05 0.0002578125 1.3883e-05 0.0002578125 1.388302e-05 0.0020078125 1.3887e-05 0.0020078125 1.388702e-05 0.0015078125 1.3891e-05 0.0015078125 \
1.389102e-05 0.0022578125 1.3895e-05 0.0022578125 1.389502e-05 0.0012578125 1.3899e-05 0.0012578125 1.389902e-05 0.0007578125 1.3903e-05 0.0007578125 1.390302e-05 0.0027578125 1.3907e-05 0.0027578125 1.390702e-05 0.0027578125 1.3911e-05 0.0027578125 1.391102e-05 0.0007578125 1.3915e-05 0.0007578125 \
1.391502e-05 0.0022578125 1.3919e-05 0.0022578125 1.391902e-05 0.0002578125 1.3923e-05 0.0002578125 1.392302e-05 0.0020078125 1.3927e-05 0.0020078125 1.392702e-05 0.0017578125 1.3931e-05 0.0017578125 1.393102e-05 0.0015078125 1.3935e-05 0.0015078125 1.393502e-05 0.0012578125 1.3939e-05 0.0012578125 \
1.393902e-05 0.0032578125]
Vinn (Vn 0) vsource type=pwl wave=[0 0.9 1.19e-07 0.9 1.1902e-07 0.9 1.23e-07 0.9 1.2302e-07 0.9005 1.27e-07 0.9005 1.2702e-07 0.89975 1.31e-07 0.89975 1.3102e-07 0.8995 1.35e-07 0.8995 1.3502e-07 0.901 1.39e-07 0.901 \
1.3902e-07 0.90025 1.43e-07 0.90025 1.4302e-07 0.8985 1.47e-07 0.8985 1.4702e-07 0.899 1.51e-07 0.899 1.5102e-07 0.9015 1.55e-07 0.9015 1.5502e-07 0.9 1.59e-07 0.9 1.5902e-07 0.899 1.63e-07 0.899 \
1.6302e-07 0.9005 1.67e-07 0.9005 1.6702e-07 0.9015 1.71e-07 0.9015 1.7102e-07 0.8995 1.75e-07 0.8995 1.7502e-07 0.901 1.79e-07 0.901 1.7902e-07 0.89975 1.83e-07 0.89975 1.8302e-07 0.90025 1.87e-07 0.90025 \
1.8702e-07 0.8985 1.91e-07 0.8985 1.9102e-07 0.901 1.95e-07 0.901 1.9502e-07 0.8985 1.99e-07 0.8985 1.9902e-07 0.9015 2.03e-07 0.9015 2.0302e-07 0.8995 2.07e-07 0.8995 2.0702e-07 0.899 2.11e-07 0.899 \
2.1102e-07 0.89975 2.15e-07 0.89975 2.1502e-07 0.9 2.19e-07 0.9 2.1902e-07 0.90025 2.23e-07 0.90025 2.2302e-07 0.9005 2.27e-07 0.9005 2.2702e-07 0.9 2.31e-07 0.9 2.3102e-07 0.89975 2.35e-07 0.89975 \
2.3502e-07 0.899 2.39e-07 0.899 2.3902e-07 0.8985 2.43e-07 0.8985 2.4302e-07 0.9005 2.47e-07 0.9005 2.4702e-07 0.90025 2.51e-07 0.90025 2.5102e-07 0.8995 2.55e-07 0.8995 2.5502e-07 0.9015 2.59e-07 0.9015 \
2.5902e-07 0.901 2.63e-07 0.901 2.6302e-07 0.9005 2.67e-07 0.9005 2.6702e-07 0.9015 2.71e-07 0.9015 2.7102e-07 0.90025 2.75e-07 0.90025 2.7502e-07 0.8985 2.79e-07 0.8985 2.7902e-07 0.899 2.83e-07 0.899 \
2.8302e-07 0.901 2.87e-07 0.901 2.8702e-07 0.9 2.91e-07 0.9 2.9102e-07 0.89975 2.95e-07 0.89975 2.9502e-07 0.8995 2.99e-07 0.8995 2.9902e-07 0.8995 3.03e-07 0.8995 3.0302e-07 0.8985 3.07e-07 0.8985 \
3.0702e-07 0.90025 3.11e-07 0.90025 3.1102e-07 0.9 3.15e-07 0.9 3.1502e-07 0.89975 3.19e-07 0.89975 3.1902e-07 0.901 3.23e-07 0.901 3.2302e-07 0.899 3.27e-07 0.899 3.2702e-07 0.9005 3.31e-07 0.9005 \
3.3102e-07 0.9015 3.35e-07 0.9015 3.3502e-07 0.9015 3.39e-07 0.9015 3.3902e-07 0.9 3.43e-07 0.9 3.4302e-07 0.9005 3.47e-07 0.9005 3.4702e-07 0.90025 3.51e-07 0.90025 3.5102e-07 0.8995 3.55e-07 0.8995 \
3.5502e-07 0.8985 3.59e-07 0.8985 3.5902e-07 0.89975 3.63e-07 0.89975 3.6302e-07 0.899 3.67e-07 0.899 3.6702e-07 0.901 3.71e-07 0.901 3.7102e-07 0.9 3.75e-07 0.9 3.7502e-07 0.9005 3.79e-07 0.9005 \
3.7902e-07 0.8995 3.83e-07 0.8995 3.8302e-07 0.9015 3.87e-07 0.9015 3.8702e-07 0.8985 3.91e-07 0.8985 3.9102e-07 0.901 3.95e-07 0.901 3.9502e-07 0.899 3.99e-07 0.899 3.9902e-07 0.89975 4.03e-07 0.89975 \
4.0302e-07 0.90025 4.07e-07 0.90025 4.0702e-07 0.901 4.11e-07 0.901 4.1102e-07 0.8995 4.15e-07 0.8995 4.1502e-07 0.9015 4.19e-07 0.9015 4.1902e-07 0.9005 4.23e-07 0.9005 4.2302e-07 0.899 4.27e-07 0.899 \
4.2702e-07 0.90025 4.31e-07 0.90025 4.3102e-07 0.8985 4.35e-07 0.8985 4.3502e-07 0.89975 4.39e-07 0.89975 4.3902e-07 0.9 4.43e-07 0.9 4.4302e-07 0.901 4.47e-07 0.901 4.4702e-07 0.90025 4.51e-07 0.90025 \
4.5102e-07 0.9015 4.55e-07 0.9015 4.5502e-07 0.899 4.59e-07 0.899 4.5902e-07 0.89975 4.63e-07 0.89975 4.6302e-07 0.8995 4.67e-07 0.8995 4.6702e-07 0.8985 4.71e-07 0.8985 4.7102e-07 0.9005 4.75e-07 0.9005 \
4.7502e-07 0.9 4.79e-07 0.9 4.7902e-07 0.8985 4.83e-07 0.8985 4.8302e-07 0.901 4.87e-07 0.901 4.8702e-07 0.89975 4.91e-07 0.89975 4.9102e-07 0.899 4.95e-07 0.899 4.9502e-07 0.9005 4.99e-07 0.9005 \
4.9902e-07 0.9 5.03e-07 0.9 5.0302e-07 0.8995 5.07e-07 0.8995 5.0702e-07 0.9015 5.11e-07 0.9015 5.1102e-07 0.90025 5.15e-07 0.90025 5.1502e-07 0.9005 5.19e-07 0.9005 5.1902e-07 0.8995 5.23e-07 0.8995 \
5.2302e-07 0.899 5.27e-07 0.899 5.2702e-07 0.90025 5.31e-07 0.90025 5.3102e-07 0.9015 5.35e-07 0.9015 5.3502e-07 0.901 5.39e-07 0.901 5.3902e-07 0.89975 5.43e-07 0.89975 5.4302e-07 0.8985 5.47e-07 0.8985 \
5.4702e-07 0.9 5.51e-07 0.9 5.5102e-07 0.9005 5.55e-07 0.9005 5.5502e-07 0.90025 5.59e-07 0.90025 5.5902e-07 0.901 5.63e-07 0.901 5.6302e-07 0.89975 5.67e-07 0.89975 5.6702e-07 0.9 5.71e-07 0.9 \
5.7102e-07 0.9015 5.75e-07 0.9015 5.7502e-07 0.8985 5.79e-07 0.8985 5.7902e-07 0.8995 5.83e-07 0.8995 5.8302e-07 0.899 5.87e-07 0.899 5.8702e-07 0.89975 5.91e-07 0.89975 5.9102e-07 0.9015 5.95e-07 0.9015 \
5.9502e-07 0.899 5.99e-07 0.899 5.9902e-07 0.9 6.03e-07 0.9 6.0302e-07 0.8995 6.07e-07 0.8995 6.0702e-07 0.9005 6.11e-07 0.9005 6.1102e-07 0.8985 6.15e-07 0.8985 6.1502e-07 0.90025 6.19e-07 0.90025 \
6.1902e-07 0.901 6.23e-07 0.901 6.2302e-07 0.901 6.27e-07 0.901 6.2702e-07 0.9015 6.31e-07 0.9015 6.3102e-07 0.89975 6.35e-07 0.89975 6.3502e-07 0.90025 6.39e-07 0.90025 6.3902e-07 0.8985 6.43e-07 0.8985 \
6.4302e-07 0.9005 6.47e-07 0.9005 6.4702e-07 0.8995 6.51e-07 0.8995 6.5102e-07 0.9 6.55e-07 0.9 6.5502e-07 0.899 6.59e-07 0.899 6.5902e-07 0.9005 6.63e-07 0.9005 6.6302e-07 0.8995 6.67e-07 0.8995 \
6.6702e-07 0.9015 6.71e-07 0.9015 6.7102e-07 0.90025 6.75e-07 0.90025 6.7502e-07 0.9 6.79e-07 0.9 6.7902e-07 0.89975 6.83e-07 0.89975 6.8302e-07 0.8985 6.87e-07 0.8985 6.8702e-07 0.899 6.91e-07 0.899 \
6.9102e-07 0.901 6.95e-07 0.901 6.9502e-07 0.90025 6.99e-07 0.90025 6.9902e-07 0.8995 7.03e-07 0.8995 7.0302e-07 0.89975 7.07e-07 0.89975 7.0702e-07 0.9 7.11e-07 0.9 7.1102e-07 0.9015 7.15e-07 0.9015 \
7.1502e-07 0.901 7.19e-07 0.901 7.1902e-07 0.9005 7.23e-07 0.9005 7.2302e-07 0.8985 7.27e-07 0.8985 7.2702e-07 0.899 7.31e-07 0.899 7.3102e-07 0.89975 7.35e-07 0.89975 7.3502e-07 0.90025 7.39e-07 0.90025 \
7.3902e-07 0.8985 7.43e-07 0.8985 7.4302e-07 0.9 7.47e-07 0.9 7.4702e-07 0.8995 7.51e-07 0.8995 7.5102e-07 0.901 7.55e-07 0.901 7.5502e-07 0.9015 7.59e-07 0.9015 7.5902e-07 0.9005 7.63e-07 0.9005 \
7.6302e-07 0.899 7.67e-07 0.899 7.6702e-07 0.9015 7.71e-07 0.9015 7.7102e-07 0.8995 7.75e-07 0.8995 7.7502e-07 0.9005 7.79e-07 0.9005 7.7902e-07 0.8985 7.83e-07 0.8985 7.8302e-07 0.899 7.87e-07 0.899 \
7.8702e-07 0.901 7.91e-07 0.901 7.9102e-07 0.89975 7.95e-07 0.89975 7.9502e-07 0.9 7.99e-07 0.9 7.9902e-07 0.90025 8.03e-07 0.90025 8.0302e-07 0.9015 8.07e-07 0.9015 8.0702e-07 0.901 8.11e-07 0.901 \
8.1102e-07 0.8995 8.15e-07 0.8995 8.1502e-07 0.9005 8.19e-07 0.9005 8.1902e-07 0.899 8.23e-07 0.899 8.2302e-07 0.9 8.27e-07 0.9 8.2702e-07 0.89975 8.31e-07 0.89975 8.3102e-07 0.8985 8.35e-07 0.8985 \
8.3502e-07 0.90025 8.39e-07 0.90025 8.3902e-07 0.901 8.43e-07 0.901 8.4302e-07 0.8985 8.47e-07 0.8985 8.4702e-07 0.90025 8.51e-07 0.90025 8.5102e-07 0.8995 8.55e-07 0.8995 8.5502e-07 0.9 8.59e-07 0.9 \
8.5902e-07 0.9015 8.63e-07 0.9015 8.6302e-07 0.899 8.67e-07 0.899 8.6702e-07 0.9005 8.71e-07 0.9005 8.7102e-07 0.89975 8.75e-07 0.89975 8.7502e-07 0.90025 8.79e-07 0.90025 8.7902e-07 0.89975 8.83e-07 0.89975 \
8.8302e-07 0.9005 8.87e-07 0.9005 8.8702e-07 0.899 8.91e-07 0.899 8.9102e-07 0.9015 8.95e-07 0.9015 8.9502e-07 0.901 8.99e-07 0.901 8.9902e-07 0.8985 9.03e-07 0.8985 9.0302e-07 0.8995 9.07e-07 0.8995 \
9.0702e-07 0.9 9.11e-07 0.9 9.1102e-07 0.9015 9.15e-07 0.9015 9.1502e-07 0.9 9.19e-07 0.9 9.1902e-07 0.89975 9.23e-07 0.89975 9.2302e-07 0.8995 9.27e-07 0.8995 9.2702e-07 0.899 9.31e-07 0.899 \
9.3102e-07 0.8985 9.35e-07 0.8985 9.3502e-07 0.901 9.39e-07 0.901 9.3902e-07 0.9005 9.43e-07 0.9005 9.4302e-07 0.90025 9.47e-07 0.90025 9.4702e-07 0.899 9.51e-07 0.899 9.5102e-07 0.89975 9.55e-07 0.89975 \
9.5502e-07 0.901 9.59e-07 0.901 9.5902e-07 0.9 9.63e-07 0.9 9.6302e-07 0.9015 9.67e-07 0.9015 9.6702e-07 0.9005 9.71e-07 0.9005 9.7102e-07 0.8995 9.75e-07 0.8995 9.7502e-07 0.90025 9.79e-07 0.90025 \
9.7902e-07 0.8985 9.83e-07 0.8985 9.8302e-07 0.8985 9.87e-07 0.8985 9.8702e-07 0.9015 9.91e-07 0.9015 9.9102e-07 0.8995 9.95e-07 0.8995 9.9502e-07 0.901 9.99e-07 0.901 9.9902e-07 0.9005 1.003e-06 0.9005 \
1.00302e-06 0.89975 1.007e-06 0.89975 1.00702e-06 0.899 1.011e-06 0.899 1.01102e-06 0.90025 1.015e-06 0.90025 1.01502e-06 0.9 1.019e-06 0.9 1.01902e-06 0.9015 1.023e-06 0.9015 1.02302e-06 0.9005 1.027e-06 0.9005 \
1.02702e-06 0.90025 1.031e-06 0.90025 1.03102e-06 0.9 1.035e-06 0.9 1.03502e-06 0.8985 1.039e-06 0.8985 1.03902e-06 0.901 1.043e-06 0.901 1.04302e-06 0.89975 1.047e-06 0.89975 1.04702e-06 0.8995 1.051e-06 0.8995 \
1.05102e-06 0.899 1.055e-06 0.899 1.05502e-06 0.8985 1.059e-06 0.8985 1.05902e-06 0.90025 1.063e-06 0.90025 1.06302e-06 0.9005 1.067e-06 0.9005 1.06702e-06 0.899 1.071e-06 0.899 1.07102e-06 0.8995 1.075e-06 0.8995 \
1.07502e-06 0.901 1.079e-06 0.901 1.07902e-06 0.9015 1.083e-06 0.9015 1.08302e-06 0.89975 1.087e-06 0.89975 1.08702e-06 0.9 1.091e-06 0.9 1.09102e-06 0.9 1.095e-06 0.9 1.09502e-06 0.8995 1.099e-06 0.8995 \
1.09902e-06 0.9015 1.103e-06 0.9015 1.10302e-06 0.90025 1.107e-06 0.90025 1.10702e-06 0.901 1.111e-06 0.901 1.11102e-06 0.9005 1.115e-06 0.9005 1.11502e-06 0.89975 1.119e-06 0.89975 1.11902e-06 0.8985 1.123e-06 0.8985 \
1.12302e-06 0.899 1.127e-06 0.899 1.12702e-06 0.89975 1.131e-06 0.89975 1.13102e-06 0.8995 1.135e-06 0.8995 1.13502e-06 0.901 1.139e-06 0.901 1.13902e-06 0.9 1.143e-06 0.9 1.14302e-06 0.9015 1.147e-06 0.9015 \
1.14702e-06 0.90025 1.151e-06 0.90025 1.15102e-06 0.8985 1.155e-06 0.8985 1.15502e-06 0.9005 1.159e-06 0.9005 1.15902e-06 0.899 1.163e-06 0.899 1.16302e-06 0.90025 1.167e-06 0.90025 1.16702e-06 0.9015 1.171e-06 0.9015 \
1.17102e-06 0.89975 1.175e-06 0.89975 1.17502e-06 0.8995 1.179e-06 0.8995 1.17902e-06 0.899 1.183e-06 0.899 1.18302e-06 0.901 1.187e-06 0.901 1.18702e-06 0.9005 1.191e-06 0.9005 1.19102e-06 0.8985 1.195e-06 0.8985 \
1.19502e-06 0.9 1.199e-06 0.9 1.19902e-06 0.901 1.203e-06 0.901 1.20302e-06 0.8985 1.207e-06 0.8985 1.20702e-06 0.9015 1.211e-06 0.9015 1.21102e-06 0.899 1.215e-06 0.899 1.21502e-06 0.9 1.219e-06 0.9 \
1.21902e-06 0.89975 1.223e-06 0.89975 1.22302e-06 0.8995 1.227e-06 0.8995 1.22702e-06 0.9005 1.231e-06 0.9005 1.23102e-06 0.90025 1.235e-06 0.90025 1.23502e-06 0.8985 1.239e-06 0.8985 1.23902e-06 0.901 1.243e-06 0.901 \
1.24302e-06 0.8995 1.247e-06 0.8995 1.24702e-06 0.899 1.251e-06 0.899 1.25102e-06 0.9005 1.255e-06 0.9005 1.25502e-06 0.90025 1.259e-06 0.90025 1.25902e-06 0.9 1.263e-06 0.9 1.26302e-06 0.89975 1.267e-06 0.89975 \
1.26702e-06 0.9015 1.271e-06 0.9015 1.27102e-06 0.9005 1.275e-06 0.9005 1.27502e-06 0.9015 1.279e-06 0.9015 1.27902e-06 0.899 1.283e-06 0.899 1.28302e-06 0.8985 1.287e-06 0.8985 1.28702e-06 0.901 1.291e-06 0.901 \
1.29102e-06 0.89975 1.295e-06 0.89975 1.29502e-06 0.90025 1.299e-06 0.90025 1.29902e-06 0.8995 1.303e-06 0.8995 1.30302e-06 0.9 1.307e-06 0.9 1.30702e-06 0.901 1.311e-06 0.901 1.31102e-06 0.89975 1.315e-06 0.89975 \
1.31502e-06 0.8995 1.319e-06 0.8995 1.31902e-06 0.9 1.323e-06 0.9 1.32302e-06 0.9005 1.327e-06 0.9005 1.32702e-06 0.899 1.331e-06 0.899 1.33102e-06 0.9015 1.335e-06 0.9015 1.33502e-06 0.8985 1.339e-06 0.8985 \
1.33902e-06 0.90025 1.343e-06 0.90025 1.34302e-06 0.9005 1.347e-06 0.9005 1.34702e-06 0.9 1.351e-06 0.9 1.35102e-06 0.9015 1.355e-06 0.9015 1.35502e-06 0.901 1.359e-06 0.901 1.35902e-06 0.8995 1.363e-06 0.8995 \
1.36302e-06 0.899 1.367e-06 0.899 1.36702e-06 0.8985 1.371e-06 0.8985 1.37102e-06 0.90025 1.375e-06 0.90025 1.37502e-06 0.89975 1.379e-06 0.89975 1.37902e-06 0.8985 1.383e-06 0.8985 1.38302e-06 0.899 1.387e-06 0.899 \
1.38702e-06 0.9005 1.391e-06 0.9005 1.39102e-06 0.8995 1.395e-06 0.8995 1.39502e-06 0.9 1.399e-06 0.9 1.39902e-06 0.901 1.403e-06 0.901 1.40302e-06 0.90025 1.407e-06 0.90025 1.40702e-06 0.9015 1.411e-06 0.9015 \
1.41102e-06 0.89975 1.415e-06 0.89975 1.41502e-06 0.899 1.419e-06 0.899 1.41902e-06 0.9 1.423e-06 0.9 1.42302e-06 0.8985 1.427e-06 0.8985 1.42702e-06 0.9005 1.431e-06 0.9005 1.43102e-06 0.89975 1.435e-06 0.89975 \
1.43502e-06 0.8995 1.439e-06 0.8995 1.43902e-06 0.90025 1.443e-06 0.90025 1.44302e-06 0.9015 1.447e-06 0.9015 1.44702e-06 0.901 1.451e-06 0.901 1.45102e-06 0.9005 1.455e-06 0.9005 1.45502e-06 0.9 1.459e-06 0.9 \
1.45902e-06 0.899 1.463e-06 0.899 1.46302e-06 0.90025 1.467e-06 0.90025 1.46702e-06 0.8985 1.471e-06 0.8985 1.47102e-06 0.8995 1.475e-06 0.8995 1.47502e-06 0.901 1.479e-06 0.901 1.47902e-06 0.89975 1.483e-06 0.89975 \
1.48302e-06 0.9015 1.487e-06 0.9015 1.48702e-06 0.8985 1.491e-06 0.8985 1.49102e-06 0.9005 1.495e-06 0.9005 1.49502e-06 0.9015 1.499e-06 0.9015 1.49902e-06 0.899 1.503e-06 0.899 1.50302e-06 0.901 1.507e-06 0.901 \
1.50702e-06 0.90025 1.511e-06 0.90025 1.51102e-06 0.9 1.515e-06 0.9 1.51502e-06 0.89975 1.519e-06 0.89975 1.51902e-06 0.8995 1.523e-06 0.8995 1.52302e-06 0.9005 1.527e-06 0.9005 1.52702e-06 0.901 1.531e-06 0.901 \
1.53102e-06 0.8985 1.535e-06 0.8985 1.53502e-06 0.9 1.539e-06 0.9 1.53902e-06 0.8995 1.543e-06 0.8995 1.54302e-06 0.90025 1.547e-06 0.90025 1.54702e-06 0.89975 1.551e-06 0.89975 1.55102e-06 0.9015 1.555e-06 0.9015 \
1.55502e-06 0.899 1.559e-06 0.899 1.55902e-06 0.901 1.563e-06 0.901 1.56302e-06 0.89975 1.567e-06 0.89975 1.56702e-06 0.8985 1.571e-06 0.8985 1.57102e-06 0.899 1.575e-06 0.899 1.57502e-06 0.9015 1.579e-06 0.9015 \
1.57902e-06 0.9005 1.583e-06 0.9005 1.58302e-06 0.9 1.587e-06 0.9 1.58702e-06 0.90025 1.591e-06 0.90025 1.59102e-06 0.8995 1.595e-06 0.8995 1.59502e-06 0.9005 1.599e-06 0.9005 1.59902e-06 0.8995 1.603e-06 0.8995 \
1.60302e-06 0.9015 1.607e-06 0.9015 1.60702e-06 0.8985 1.611e-06 0.8985 1.61102e-06 0.899 1.615e-06 0.899 1.61502e-06 0.89975 1.619e-06 0.89975 1.61902e-06 0.901 1.623e-06 0.901 1.62302e-06 0.90025 1.627e-06 0.90025 \
1.62702e-06 0.9 1.631e-06 0.9 1.63102e-06 0.9015 1.635e-06 0.9015 1.63502e-06 0.901 1.639e-06 0.901 1.63902e-06 0.9 1.643e-06 0.9 1.64302e-06 0.8995 1.647e-06 0.8995 1.64702e-06 0.899 1.651e-06 0.899 \
1.65102e-06 0.9005 1.655e-06 0.9005 1.65502e-06 0.90025 1.659e-06 0.90025 1.65902e-06 0.8985 1.663e-06 0.8985 1.66302e-06 0.89975 1.667e-06 0.89975 1.66702e-06 0.9 1.671e-06 0.9 1.67102e-06 0.90025 1.675e-06 0.90025 \
1.67502e-06 0.9015 1.679e-06 0.9015 1.67902e-06 0.9005 1.683e-06 0.9005 1.68302e-06 0.8995 1.687e-06 0.8995 1.68702e-06 0.8985 1.691e-06 0.8985 1.69102e-06 0.899 1.695e-06 0.899 1.69502e-06 0.901 1.699e-06 0.901 \
1.69902e-06 0.89975 1.703e-06 0.89975 1.70302e-06 0.8985 1.707e-06 0.8985 1.70702e-06 0.8995 1.711e-06 0.8995 1.71102e-06 0.9015 1.715e-06 0.9015 1.71502e-06 0.899 1.719e-06 0.899 1.71902e-06 0.90025 1.723e-06 0.90025 \
1.72302e-06 0.89975 1.727e-06 0.89975 1.72702e-06 0.9005 1.731e-06 0.9005 1.73102e-06 0.9 1.735e-06 0.9 1.73502e-06 0.901 1.739e-06 0.901 1.73902e-06 0.8995 1.743e-06 0.8995 1.74302e-06 0.9015 1.747e-06 0.9015 \
1.74702e-06 0.899 1.751e-06 0.899 1.75102e-06 0.89975 1.755e-06 0.89975 1.75502e-06 0.90025 1.759e-06 0.90025 1.75902e-06 0.9 1.763e-06 0.9 1.76302e-06 0.9005 1.767e-06 0.9005 1.76702e-06 0.901 1.771e-06 0.901 \
1.77102e-06 0.8985 1.775e-06 0.8985 1.77502e-06 0.89975 1.779e-06 0.89975 1.77902e-06 0.90025 1.783e-06 0.90025 1.78302e-06 0.8985 1.787e-06 0.8985 1.78702e-06 0.9 1.791e-06 0.9 1.79102e-06 0.9005 1.795e-06 0.9005 \
1.79502e-06 0.9015 1.799e-06 0.9015 1.79902e-06 0.901 1.803e-06 0.901 1.80302e-06 0.899 1.807e-06 0.899 1.80702e-06 0.8995 1.811e-06 0.8995 1.81102e-06 0.90025 1.815e-06 0.90025 1.81502e-06 0.9 1.819e-06 0.9 \
1.81902e-06 0.89975 1.823e-06 0.89975 1.82302e-06 0.901 1.827e-06 0.901 1.82702e-06 0.899 1.831e-06 0.899 1.83102e-06 0.9005 1.835e-06 0.9005 1.83502e-06 0.8995 1.839e-06 0.8995 1.83902e-06 0.9015 1.843e-06 0.9015 \
1.84302e-06 0.8985 1.847e-06 0.8985 1.84702e-06 0.9015 1.851e-06 0.9015 1.85102e-06 0.901 1.855e-06 0.901 1.85502e-06 0.89975 1.859e-06 0.89975 1.85902e-06 0.8995 1.863e-06 0.8995 1.86302e-06 0.90025 1.867e-06 0.90025 \
1.86702e-06 0.899 1.871e-06 0.899 1.87102e-06 0.8985 1.875e-06 0.8985 1.87502e-06 0.9005 1.879e-06 0.9005 1.87902e-06 0.9 1.883e-06 0.9 1.88302e-06 0.90025 1.887e-06 0.90025 1.88702e-06 0.9015 1.891e-06 0.9015 \
1.89102e-06 0.9005 1.895e-06 0.9005 1.89502e-06 0.8995 1.899e-06 0.8995 1.89902e-06 0.899 1.903e-06 0.899 1.90302e-06 0.8985 1.907e-06 0.8985 1.90702e-06 0.89975 1.911e-06 0.89975 1.91102e-06 0.901 1.915e-06 0.901 \
1.91502e-06 0.9 1.919e-06 0.9 1.91902e-06 0.8985 1.923e-06 0.8985 1.92302e-06 0.9015 1.927e-06 0.9015 1.92702e-06 0.89975 1.931e-06 0.89975 1.93102e-06 0.9 1.935e-06 0.9 1.93502e-06 0.901 1.939e-06 0.901 \
1.93902e-06 0.8995 1.943e-06 0.8995 1.94302e-06 0.90025 1.947e-06 0.90025 1.94702e-06 0.9005 1.951e-06 0.9005 1.95102e-06 0.899 1.955e-06 0.899 1.95502e-06 0.9 1.959e-06 0.9 1.95902e-06 0.8985 1.963e-06 0.8985 \
1.96302e-06 0.9015 1.967e-06 0.9015 1.96702e-06 0.9005 1.971e-06 0.9005 1.97102e-06 0.899 1.975e-06 0.899 1.97502e-06 0.901 1.979e-06 0.901 1.97902e-06 0.90025 1.983e-06 0.90025 1.98302e-06 0.8995 1.987e-06 0.8995 \
1.98702e-06 0.89975 1.991e-06 0.89975 1.99102e-06 0.8995 1.995e-06 0.8995 1.99502e-06 0.9 1.999e-06 0.9 1.99902e-06 0.9015 2.003e-06 0.9015 2.00302e-06 0.9005 2.007e-06 0.9005 2.00702e-06 0.899 2.011e-06 0.899 \
2.01102e-06 0.901 2.015e-06 0.901 2.01502e-06 0.8985 2.019e-06 0.8985 2.01902e-06 0.90025 2.023e-06 0.90025 2.02302e-06 0.89975 2.027e-06 0.89975 2.02702e-06 0.8995 2.031e-06 0.8995 2.03102e-06 0.89975 2.035e-06 0.89975 \
2.03502e-06 0.9015 2.039e-06 0.9015 2.03902e-06 0.8985 2.043e-06 0.8985 2.04302e-06 0.9005 2.047e-06 0.9005 2.04702e-06 0.90025 2.051e-06 0.90025 2.05102e-06 0.9 2.055e-06 0.9 2.05502e-06 0.899 2.059e-06 0.899 \
2.05902e-06 0.901 2.063e-06 0.901 2.06302e-06 0.899 2.067e-06 0.899 2.06702e-06 0.9 2.071e-06 0.9 2.07102e-06 0.90025 2.075e-06 0.90025 2.07502e-06 0.8985 2.079e-06 0.8985 2.07902e-06 0.89975 2.083e-06 0.89975 \
2.08302e-06 0.8995 2.087e-06 0.8995 2.08702e-06 0.9015 2.091e-06 0.9015 2.09102e-06 0.901 2.095e-06 0.901 2.09502e-06 0.9005 2.099e-06 0.9005 2.09902e-06 0.899 2.103e-06 0.899 2.10302e-06 0.9015 2.107e-06 0.9015 \
2.10702e-06 0.9 2.111e-06 0.9 2.11102e-06 0.8995 2.115e-06 0.8995 2.11502e-06 0.89975 2.119e-06 0.89975 2.11902e-06 0.8985 2.123e-06 0.8985 2.12302e-06 0.9005 2.127e-06 0.9005 2.12702e-06 0.901 2.131e-06 0.901 \
2.13102e-06 0.90025 2.135e-06 0.90025 2.13502e-06 0.9005 2.139e-06 0.9005 2.13902e-06 0.90025 2.143e-06 0.90025 2.14302e-06 0.901 2.147e-06 0.901 2.14702e-06 0.8985 2.151e-06 0.8985 2.15102e-06 0.89975 2.155e-06 0.89975 \
2.15502e-06 0.9015 2.159e-06 0.9015 2.15902e-06 0.899 2.163e-06 0.899 2.16302e-06 0.8995 2.167e-06 0.8995 2.16702e-06 0.9 2.171e-06 0.9 2.17102e-06 0.8995 2.175e-06 0.8995 2.17502e-06 0.90025 2.179e-06 0.90025 \
2.17902e-06 0.899 2.183e-06 0.899 2.18302e-06 0.9005 2.187e-06 0.9005 2.18702e-06 0.9015 2.191e-06 0.9015 2.19102e-06 0.89975 2.195e-06 0.89975 2.19502e-06 0.901 2.199e-06 0.901 2.19902e-06 0.9 2.203e-06 0.9 \
2.20302e-06 0.8985 2.207e-06 0.8985 2.20702e-06 0.901 2.211e-06 0.901 2.21102e-06 0.90025 2.215e-06 0.90025 2.21502e-06 0.899 2.219e-06 0.899 2.21902e-06 0.9005 2.223e-06 0.9005 2.22302e-06 0.9015 2.227e-06 0.9015 \
2.22702e-06 0.89975 2.231e-06 0.89975 2.23102e-06 0.8985 2.235e-06 0.8985 2.23502e-06 0.9 2.239e-06 0.9 2.23902e-06 0.8995 2.243e-06 0.8995 2.24302e-06 0.9005 2.247e-06 0.9005 2.24702e-06 0.9015 2.251e-06 0.9015 \
2.25102e-06 0.8995 2.255e-06 0.8995 2.25502e-06 0.901 2.259e-06 0.901 2.25902e-06 0.8985 2.263e-06 0.8985 2.26302e-06 0.90025 2.267e-06 0.90025 2.26702e-06 0.9 2.271e-06 0.9 2.27102e-06 0.89975 2.275e-06 0.89975 \
2.27502e-06 0.899 2.279e-06 0.899 2.27902e-06 0.899 2.283e-06 0.899 2.28302e-06 0.89975 2.287e-06 0.89975 2.28702e-06 0.9005 2.291e-06 0.9005 2.29102e-06 0.8995 2.295e-06 0.8995 2.29502e-06 0.9015 2.299e-06 0.9015 \
2.29902e-06 0.9 2.303e-06 0.9 2.30302e-06 0.901 2.307e-06 0.901 2.30702e-06 0.90025 2.311e-06 0.90025 2.31102e-06 0.8985 2.315e-06 0.8985 2.31502e-06 0.8985 2.319e-06 0.8985 2.31902e-06 0.89975 2.323e-06 0.89975 \
2.32302e-06 0.9015 2.327e-06 0.9015 2.32702e-06 0.8995 2.331e-06 0.8995 2.33102e-06 0.9005 2.335e-06 0.9005 2.33502e-06 0.901 2.339e-06 0.901 2.33902e-06 0.899 2.343e-06 0.899 2.34302e-06 0.90025 2.347e-06 0.90025 \
2.34702e-06 0.9 2.351e-06 0.9 2.35102e-06 0.9015 2.355e-06 0.9015 2.35502e-06 0.90025 2.359e-06 0.90025 2.35902e-06 0.8995 2.363e-06 0.8995 2.36302e-06 0.9 2.367e-06 0.9 2.36702e-06 0.8985 2.371e-06 0.8985 \
2.37102e-06 0.9005 2.375e-06 0.9005 2.37502e-06 0.901 2.379e-06 0.901 2.37902e-06 0.89975 2.383e-06 0.89975 2.38302e-06 0.899 2.387e-06 0.899 2.38702e-06 0.9005 2.391e-06 0.9005 2.39102e-06 0.901 2.395e-06 0.901 \
2.39502e-06 0.89975 2.399e-06 0.89975 2.39902e-06 0.9015 2.403e-06 0.9015 2.40302e-06 0.9 2.407e-06 0.9 2.40702e-06 0.8985 2.411e-06 0.8985 2.41102e-06 0.899 2.415e-06 0.899 2.41502e-06 0.90025 2.419e-06 0.90025 \
2.41902e-06 0.8995 2.423e-06 0.8995 2.42302e-06 0.9005 2.427e-06 0.9005 2.42702e-06 0.901 2.431e-06 0.901 2.43102e-06 0.9015 2.435e-06 0.9015 2.43502e-06 0.899 2.439e-06 0.899 2.43902e-06 0.90025 2.443e-06 0.90025 \
2.44302e-06 0.8995 2.447e-06 0.8995 2.44702e-06 0.9 2.451e-06 0.9 2.45102e-06 0.89975 2.455e-06 0.89975 2.45502e-06 0.8985 2.459e-06 0.8985 2.45902e-06 0.90025 2.463e-06 0.90025 2.46302e-06 0.9005 2.467e-06 0.9005 \
2.46702e-06 0.89975 2.471e-06 0.89975 2.47102e-06 0.8995 2.475e-06 0.8995 2.47502e-06 0.9 2.479e-06 0.9 2.47902e-06 0.901 2.483e-06 0.901 2.48302e-06 0.8985 2.487e-06 0.8985 2.48702e-06 0.9015 2.491e-06 0.9015 \
2.49102e-06 0.899 2.495e-06 0.899 2.49502e-06 0.9005 2.499e-06 0.9005 2.49902e-06 0.8985 2.503e-06 0.8985 2.50302e-06 0.89975 2.507e-06 0.89975 2.50702e-06 0.899 2.511e-06 0.899 2.51102e-06 0.901 2.515e-06 0.901 \
2.51502e-06 0.90025 2.519e-06 0.90025 2.51902e-06 0.9015 2.523e-06 0.9015 2.52302e-06 0.9 2.527e-06 0.9 2.52702e-06 0.8995 2.531e-06 0.8995 2.53102e-06 0.9015 2.535e-06 0.9015 2.53502e-06 0.8985 2.539e-06 0.8985 \
2.53902e-06 0.899 2.543e-06 0.899 2.54302e-06 0.9 2.547e-06 0.9 2.54702e-06 0.901 2.551e-06 0.901 2.55102e-06 0.90025 2.555e-06 0.90025 2.55502e-06 0.89975 2.559e-06 0.89975 2.55902e-06 0.9005 2.563e-06 0.9005 \
2.56302e-06 0.8995 2.567e-06 0.8995 2.56702e-06 0.90025 2.571e-06 0.90025 2.57102e-06 0.8985 2.575e-06 0.8985 2.57502e-06 0.901 2.579e-06 0.901 2.57902e-06 0.9 2.583e-06 0.9 2.58302e-06 0.899 2.587e-06 0.899 \
2.58702e-06 0.8995 2.591e-06 0.8995 2.59102e-06 0.9005 2.595e-06 0.9005 2.59502e-06 0.9015 2.599e-06 0.9015 2.59902e-06 0.89975 2.603e-06 0.89975 2.60302e-06 0.9005 2.607e-06 0.9005 2.60702e-06 0.901 2.611e-06 0.901 \
2.61102e-06 0.8995 2.615e-06 0.8995 2.61502e-06 0.90025 2.619e-06 0.90025 2.61902e-06 0.8985 2.623e-06 0.8985 2.62302e-06 0.9 2.627e-06 0.9 2.62702e-06 0.89975 2.631e-06 0.89975 2.63102e-06 0.899 2.635e-06 0.899 \
2.63502e-06 0.9015 2.639e-06 0.9015 2.63902e-06 0.90025 2.643e-06 0.90025 2.64302e-06 0.899 2.647e-06 0.899 2.64702e-06 0.89975 2.651e-06 0.89975 2.65102e-06 0.9005 2.655e-06 0.9005 2.65502e-06 0.9015 2.659e-06 0.9015 \
2.65902e-06 0.901 2.663e-06 0.901 2.66302e-06 0.8985 2.667e-06 0.8985 2.66702e-06 0.9 2.671e-06 0.9 2.67102e-06 0.8995 2.675e-06 0.8995 2.67502e-06 0.8995 2.679e-06 0.8995 2.67902e-06 0.8985 2.683e-06 0.8985 \
2.68302e-06 0.90025 2.687e-06 0.90025 2.68702e-06 0.899 2.691e-06 0.899 2.69102e-06 0.9015 2.695e-06 0.9015 2.69502e-06 0.901 2.699e-06 0.901 2.69902e-06 0.9005 2.703e-06 0.9005 2.70302e-06 0.89975 2.707e-06 0.89975 \
2.70702e-06 0.9 2.711e-06 0.9 2.71102e-06 0.9 2.715e-06 0.9 2.71502e-06 0.8985 2.719e-06 0.8985 2.71902e-06 0.89975 2.723e-06 0.89975 2.72302e-06 0.8995 2.727e-06 0.8995 2.72702e-06 0.9005 2.731e-06 0.9005 \
2.73102e-06 0.9015 2.735e-06 0.9015 2.73502e-06 0.899 2.739e-06 0.899 2.73902e-06 0.90025 2.743e-06 0.90025 2.74302e-06 0.901 2.747e-06 0.901 2.74702e-06 0.8985 2.751e-06 0.8985 2.75102e-06 0.9005 2.755e-06 0.9005 \
2.75502e-06 0.89975 2.759e-06 0.89975 2.75902e-06 0.899 2.763e-06 0.899 2.76302e-06 0.90025 2.767e-06 0.90025 2.76702e-06 0.9 2.771e-06 0.9 2.77102e-06 0.8995 2.775e-06 0.8995 2.77502e-06 0.9015 2.779e-06 0.9015 \
2.77902e-06 0.901 2.783e-06 0.901 2.78302e-06 0.901 2.787e-06 0.901 2.78702e-06 0.8995 2.791e-06 0.8995 2.79102e-06 0.9 2.795e-06 0.9 2.79502e-06 0.89975 2.799e-06 0.89975 2.79902e-06 0.8985 2.803e-06 0.8985 \
2.80302e-06 0.9015 2.807e-06 0.9015 2.80702e-06 0.899 2.811e-06 0.899 2.81102e-06 0.9005 2.815e-06 0.9005 2.81502e-06 0.90025 2.819e-06 0.90025 2.81902e-06 0.89975 2.823e-06 0.89975 2.82302e-06 0.8985 2.827e-06 0.8985 \
2.82702e-06 0.9015 2.831e-06 0.9015 2.83102e-06 0.9 2.835e-06 0.9 2.83502e-06 0.8995 2.839e-06 0.8995 2.83902e-06 0.90025 2.843e-06 0.90025 2.84302e-06 0.899 2.847e-06 0.899 2.84702e-06 0.9005 2.851e-06 0.9005 \
2.85102e-06 0.901 2.855e-06 0.901 2.85502e-06 0.8985 2.859e-06 0.8985 2.85902e-06 0.89975 2.863e-06 0.89975 2.86302e-06 0.899 2.867e-06 0.899 2.86702e-06 0.901 2.871e-06 0.901 2.87102e-06 0.8995 2.875e-06 0.8995 \
2.87502e-06 0.9 2.879e-06 0.9 2.87902e-06 0.90025 2.883e-06 0.90025 2.88302e-06 0.9005 2.887e-06 0.9005 2.88702e-06 0.9015 2.891e-06 0.9015 2.89102e-06 0.901 2.895e-06 0.901 2.89502e-06 0.89975 2.899e-06 0.89975 \
2.89902e-06 0.8985 2.903e-06 0.8985 2.90302e-06 0.9005 2.907e-06 0.9005 2.90702e-06 0.9 2.911e-06 0.9 2.91102e-06 0.899 2.915e-06 0.899 2.91502e-06 0.8995 2.919e-06 0.8995 2.91902e-06 0.9015 2.923e-06 0.9015 \
2.92302e-06 0.90025 2.927e-06 0.90025 2.92702e-06 0.89975 2.931e-06 0.89975 2.93102e-06 0.9 2.935e-06 0.9 2.93502e-06 0.899 2.939e-06 0.899 2.93902e-06 0.8995 2.943e-06 0.8995 2.94302e-06 0.901 2.947e-06 0.901 \
2.94702e-06 0.8985 2.951e-06 0.8985 2.95102e-06 0.9015 2.955e-06 0.9015 2.95502e-06 0.9005 2.959e-06 0.9005 2.95902e-06 0.90025 2.963e-06 0.90025 2.96302e-06 0.9015 2.967e-06 0.9015 2.96702e-06 0.899 2.971e-06 0.899 \
2.97102e-06 0.9 2.975e-06 0.9 2.97502e-06 0.8985 2.979e-06 0.8985 2.97902e-06 0.90025 2.983e-06 0.90025 2.98302e-06 0.9005 2.987e-06 0.9005 2.98702e-06 0.8995 2.991e-06 0.8995 2.99102e-06 0.901 2.995e-06 0.901 \
2.99502e-06 0.89975 2.999e-06 0.89975 2.99902e-06 0.901 3.003e-06 0.901 3.00302e-06 0.899 3.007e-06 0.899 3.00702e-06 0.89975 3.011e-06 0.89975 3.01102e-06 0.90025 3.015e-06 0.90025 3.01502e-06 0.9015 3.019e-06 0.9015 \
3.01902e-06 0.9005 3.023e-06 0.9005 3.02302e-06 0.9 3.027e-06 0.9 3.02702e-06 0.8995 3.031e-06 0.8995 3.03102e-06 0.8985 3.035e-06 0.8985 3.03502e-06 0.8985 3.039e-06 0.8985 3.03902e-06 0.90025 3.043e-06 0.90025 \
3.04302e-06 0.9 3.047e-06 0.9 3.04702e-06 0.8995 3.051e-06 0.8995 3.05102e-06 0.899 3.055e-06 0.899 3.05502e-06 0.901 3.059e-06 0.901 3.05902e-06 0.9015 3.063e-06 0.9015 3.06302e-06 0.89975 3.067e-06 0.89975 \
3.06702e-06 0.9005 3.071e-06 0.9005 3.07102e-06 0.8985 3.075e-06 0.8985 3.07502e-06 0.899 3.079e-06 0.899 3.07902e-06 0.9015 3.083e-06 0.9015 3.08302e-06 0.9005 3.087e-06 0.9005 3.08702e-06 0.901 3.091e-06 0.901 \
3.09102e-06 0.9 3.095e-06 0.9 3.09502e-06 0.8995 3.099e-06 0.8995 3.09902e-06 0.89975 3.103e-06 0.89975 3.10302e-06 0.90025 3.107e-06 0.90025 3.10702e-06 0.899 3.111e-06 0.899 3.11102e-06 0.901 3.115e-06 0.901 \
3.11502e-06 0.9015 3.119e-06 0.9015 3.11902e-06 0.89975 3.123e-06 0.89975 3.12302e-06 0.8985 3.127e-06 0.8985 3.12702e-06 0.9005 3.131e-06 0.9005 3.13102e-06 0.90025 3.135e-06 0.90025 3.13502e-06 0.8995 3.139e-06 0.8995 \
3.13902e-06 0.9 3.143e-06 0.9 3.14302e-06 0.9015 3.147e-06 0.9015 3.14702e-06 0.899 3.151e-06 0.899 3.15102e-06 0.9 3.155e-06 0.9 3.15502e-06 0.9005 3.159e-06 0.9005 3.15902e-06 0.8985 3.163e-06 0.8985 \
3.16302e-06 0.8995 3.167e-06 0.8995 3.16702e-06 0.89975 3.171e-06 0.89975 3.17102e-06 0.901 3.175e-06 0.901 3.17502e-06 0.90025 3.179e-06 0.90025 3.17902e-06 0.9 3.183e-06 0.9 3.18302e-06 0.9015 3.187e-06 0.9015 \
3.18702e-06 0.899 3.191e-06 0.899 3.19102e-06 0.90025 3.195e-06 0.90025 3.19502e-06 0.901 3.199e-06 0.901 3.19902e-06 0.89975 3.203e-06 0.89975 3.20302e-06 0.8995 3.207e-06 0.8995 3.20702e-06 0.9005 3.211e-06 0.9005 \
3.21102e-06 0.8985 3.215e-06 0.8985 3.21502e-06 0.8985 3.219e-06 0.8985 3.21902e-06 0.901 3.223e-06 0.901 3.22302e-06 0.90025 3.227e-06 0.90025 3.22702e-06 0.89975 3.231e-06 0.89975 3.23102e-06 0.899 3.235e-06 0.899 \
3.23502e-06 0.9005 3.239e-06 0.9005 3.23902e-06 0.8995 3.243e-06 0.8995 3.24302e-06 0.9 3.247e-06 0.9 3.24702e-06 0.9015 3.251e-06 0.9015 3.25102e-06 0.901 3.255e-06 0.901 3.25502e-06 0.899 3.259e-06 0.899 \
3.25902e-06 0.9005 3.263e-06 0.9005 3.26302e-06 0.9015 3.267e-06 0.9015 3.26702e-06 0.8995 3.271e-06 0.8995 3.27102e-06 0.90025 3.275e-06 0.90025 3.27502e-06 0.8985 3.279e-06 0.8985 3.27902e-06 0.89975 3.283e-06 0.89975 \
3.28302e-06 0.9 3.287e-06 0.9 3.28702e-06 0.8995 3.291e-06 0.8995 3.29102e-06 0.90025 3.295e-06 0.90025 3.29502e-06 0.901 3.299e-06 0.901 3.29902e-06 0.8985 3.303e-06 0.8985 3.30302e-06 0.9005 3.307e-06 0.9005 \
3.30702e-06 0.9 3.311e-06 0.9 3.31102e-06 0.9015 3.315e-06 0.9015 3.31502e-06 0.89975 3.319e-06 0.89975 3.31902e-06 0.899 3.323e-06 0.899 3.32302e-06 0.90025 3.327e-06 0.90025 3.32702e-06 0.901 3.331e-06 0.901 \
3.33102e-06 0.9005 3.335e-06 0.9005 3.33502e-06 0.9 3.339e-06 0.9 3.33902e-06 0.899 3.343e-06 0.899 3.34302e-06 0.89975 3.347e-06 0.89975 3.34702e-06 0.8985 3.351e-06 0.8985 3.35102e-06 0.8995 3.355e-06 0.8995 \
3.35502e-06 0.9015 3.359e-06 0.9015 3.35902e-06 0.9015 3.363e-06 0.9015 3.36302e-06 0.901 3.367e-06 0.901 3.36702e-06 0.9005 3.371e-06 0.9005 3.37102e-06 0.9 3.375e-06 0.9 3.37502e-06 0.899 3.379e-06 0.899 \
3.37902e-06 0.89975 3.383e-06 0.89975 3.38302e-06 0.8985 3.387e-06 0.8985 3.38702e-06 0.8995 3.391e-06 0.8995 3.39102e-06 0.90025 3.395e-06 0.90025 3.39502e-06 0.90025 3.399e-06 0.90025 3.39902e-06 0.8995 3.403e-06 0.8995 \
3.40302e-06 0.8985 3.407e-06 0.8985 3.40702e-06 0.899 3.411e-06 0.899 3.41102e-06 0.9015 3.415e-06 0.9015 3.41502e-06 0.89975 3.419e-06 0.89975 3.41902e-06 0.9 3.423e-06 0.9 3.42302e-06 0.901 3.427e-06 0.901 \
3.42702e-06 0.9005 3.431e-06 0.9005 3.43102e-06 0.899 3.435e-06 0.899 3.43502e-06 0.901 3.439e-06 0.901 3.43902e-06 0.9005 3.443e-06 0.9005 3.44302e-06 0.89975 3.447e-06 0.89975 3.44702e-06 0.9 3.451e-06 0.9 \
3.45102e-06 0.8985 3.455e-06 0.8985 3.45502e-06 0.9015 3.459e-06 0.9015 3.45902e-06 0.8995 3.463e-06 0.8995 3.46302e-06 0.90025 3.467e-06 0.90025 3.46702e-06 0.8995 3.471e-06 0.8995 3.47102e-06 0.899 3.475e-06 0.899 \
3.47502e-06 0.90025 3.479e-06 0.90025 3.47902e-06 0.901 3.483e-06 0.901 3.48302e-06 0.9 3.487e-06 0.9 3.48702e-06 0.9015 3.491e-06 0.9015 3.49102e-06 0.89975 3.495e-06 0.89975 3.49502e-06 0.9005 3.499e-06 0.9005 \
3.49902e-06 0.8985 3.503e-06 0.8985 3.50302e-06 0.8985 3.507e-06 0.8985 3.50702e-06 0.90025 3.511e-06 0.90025 3.51102e-06 0.899 3.515e-06 0.899 3.51502e-06 0.901 3.519e-06 0.901 3.51902e-06 0.89975 3.523e-06 0.89975 \
3.52302e-06 0.9005 3.527e-06 0.9005 3.52702e-06 0.9 3.531e-06 0.9 3.53102e-06 0.9015 3.535e-06 0.9015 3.53502e-06 0.8995 3.539e-06 0.8995 3.53902e-06 0.9015 3.543e-06 0.9015 3.54302e-06 0.8995 3.547e-06 0.8995 \
3.54702e-06 0.9005 3.551e-06 0.9005 3.55102e-06 0.8985 3.555e-06 0.8985 3.55502e-06 0.899 3.559e-06 0.899 3.55902e-06 0.9 3.563e-06 0.9 3.56302e-06 0.90025 3.567e-06 0.90025 3.56702e-06 0.89975 3.571e-06 0.89975 \
3.57102e-06 0.901 3.575e-06 0.901 3.57502e-06 0.9005 3.579e-06 0.9005 3.57902e-06 0.8995 3.583e-06 0.8995 3.58302e-06 0.899 3.587e-06 0.899 3.58702e-06 0.901 3.591e-06 0.901 3.59102e-06 0.8985 3.595e-06 0.8985 \
3.59502e-06 0.9015 3.599e-06 0.9015 3.59902e-06 0.89975 3.603e-06 0.89975 3.60302e-06 0.9 3.607e-06 0.9 3.60702e-06 0.90025 3.611e-06 0.90025 3.61102e-06 0.9005 3.615e-06 0.9005 3.61502e-06 0.8995 3.619e-06 0.8995 \
3.61902e-06 0.899 3.623e-06 0.899 3.62302e-06 0.89975 3.627e-06 0.89975 3.62702e-06 0.9015 3.631e-06 0.9015 3.63102e-06 0.90025 3.635e-06 0.90025 3.63502e-06 0.901 3.639e-06 0.901 3.63902e-06 0.9 3.643e-06 0.9 \
3.64302e-06 0.8985 3.647e-06 0.8985 3.64702e-06 0.899 3.651e-06 0.899 3.65102e-06 0.9 3.655e-06 0.9 3.65502e-06 0.9015 3.659e-06 0.9015 3.65902e-06 0.90025 3.663e-06 0.90025 3.66302e-06 0.8995 3.667e-06 0.8995 \
3.66702e-06 0.901 3.671e-06 0.901 3.67102e-06 0.9005 3.675e-06 0.9005 3.67502e-06 0.89975 3.679e-06 0.89975 3.67902e-06 0.8985 3.683e-06 0.8985 3.68302e-06 0.9005 3.687e-06 0.9005 3.68702e-06 0.8985 3.691e-06 0.8985 \
3.69102e-06 0.9 3.695e-06 0.9 3.69502e-06 0.899 3.699e-06 0.899 3.69902e-06 0.90025 3.703e-06 0.90025 3.70302e-06 0.901 3.707e-06 0.901 3.70702e-06 0.8995 3.711e-06 0.8995 3.71102e-06 0.9015 3.715e-06 0.9015 \
3.71502e-06 0.89975 3.719e-06 0.89975 3.71902e-06 0.90025 3.723e-06 0.90025 3.72302e-06 0.8985 3.727e-06 0.8985 3.72702e-06 0.901 3.731e-06 0.901 3.73102e-06 0.9 3.735e-06 0.9 3.73502e-06 0.9005 3.739e-06 0.9005 \
3.73902e-06 0.89975 3.743e-06 0.89975 3.74302e-06 0.8995 3.747e-06 0.8995 3.74702e-06 0.9015 3.751e-06 0.9015 3.75102e-06 0.899 3.755e-06 0.899 3.75502e-06 0.90025 3.759e-06 0.90025 3.75902e-06 0.9005 3.763e-06 0.9005 \
3.76302e-06 0.9 3.767e-06 0.9 3.76702e-06 0.9015 3.771e-06 0.9015 3.77102e-06 0.8995 3.775e-06 0.8995 3.77502e-06 0.8985 3.779e-06 0.8985 3.77902e-06 0.899 3.783e-06 0.899 3.78302e-06 0.901 3.787e-06 0.901 \
3.78702e-06 0.89975 3.791e-06 0.89975 3.79102e-06 0.8985 3.795e-06 0.8985 3.79502e-06 0.9015 3.799e-06 0.9015 3.79902e-06 0.901 3.803e-06 0.901 3.80302e-06 0.899 3.807e-06 0.899 3.80702e-06 0.9005 3.811e-06 0.9005 \
3.81102e-06 0.89975 3.815e-06 0.89975 3.81502e-06 0.8995 3.819e-06 0.8995 3.81902e-06 0.9 3.823e-06 0.9 3.82302e-06 0.90025 3.827e-06 0.90025 3.82702e-06 0.89975 3.831e-06 0.89975 3.83102e-06 0.8985 3.835e-06 0.8985 \
3.83502e-06 0.9015 3.839e-06 0.9015 3.83902e-06 0.90025 3.843e-06 0.90025 3.84302e-06 0.8995 3.847e-06 0.8995 3.84702e-06 0.901 3.851e-06 0.901 3.85102e-06 0.9005 3.855e-06 0.9005 3.85502e-06 0.899 3.859e-06 0.899 \
3.85902e-06 0.9 3.863e-06 0.9 3.86302e-06 0.9015 3.867e-06 0.9015 3.86702e-06 0.901 3.871e-06 0.901 3.87102e-06 0.90025 3.875e-06 0.90025 3.87502e-06 0.9005 3.879e-06 0.9005 3.87902e-06 0.8985 3.883e-06 0.8985 \
3.88302e-06 0.899 3.887e-06 0.899 3.88702e-06 0.8995 3.891e-06 0.8995 3.89102e-06 0.9 3.895e-06 0.9 3.89502e-06 0.89975 3.899e-06 0.89975 3.89902e-06 0.901 3.903e-06 0.901 3.90302e-06 0.90025 3.907e-06 0.90025 \
3.90702e-06 0.89975 3.911e-06 0.89975 3.91102e-06 0.8995 3.915e-06 0.8995 3.91502e-06 0.9005 3.919e-06 0.9005 3.91902e-06 0.9015 3.923e-06 0.9015 3.92302e-06 0.899 3.927e-06 0.899 3.92702e-06 0.9 3.931e-06 0.9 \
3.93102e-06 0.8985 3.935e-06 0.8985 3.93502e-06 0.8995 3.939e-06 0.8995 3.93902e-06 0.89975 3.943e-06 0.89975 3.94302e-06 0.901 3.947e-06 0.901 3.94702e-06 0.9015 3.951e-06 0.9015 3.95102e-06 0.899 3.955e-06 0.899 \
3.95502e-06 0.9 3.959e-06 0.9 3.95902e-06 0.8985 3.963e-06 0.8985 3.96302e-06 0.90025 3.967e-06 0.90025 3.96702e-06 0.9005 3.971e-06 0.9005 3.97102e-06 0.9 3.975e-06 0.9 3.97502e-06 0.8985 3.979e-06 0.8985 \
3.97902e-06 0.89975 3.983e-06 0.89975 3.98302e-06 0.8995 3.987e-06 0.8995 3.98702e-06 0.899 3.991e-06 0.899 3.99102e-06 0.9005 3.995e-06 0.9005 3.99502e-06 0.9015 3.999e-06 0.9015 3.99902e-06 0.90025 4.003e-06 0.90025 \
4.00302e-06 0.901 4.007e-06 0.901 4.00702e-06 0.9015 4.011e-06 0.9015 4.01102e-06 0.89975 4.015e-06 0.89975 4.01502e-06 0.901 4.019e-06 0.901 4.01902e-06 0.899 4.023e-06 0.899 4.02302e-06 0.9 4.027e-06 0.9 \
4.02702e-06 0.8985 4.031e-06 0.8985 4.03102e-06 0.90025 4.035e-06 0.90025 4.03502e-06 0.9005 4.039e-06 0.9005 4.03902e-06 0.8995 4.043e-06 0.8995 4.04302e-06 0.90025 4.047e-06 0.90025 4.04702e-06 0.9 4.051e-06 0.9 \
4.05102e-06 0.9015 4.055e-06 0.9015 4.05502e-06 0.8985 4.059e-06 0.8985 4.05902e-06 0.899 4.063e-06 0.899 4.06302e-06 0.901 4.067e-06 0.901 4.06702e-06 0.8995 4.071e-06 0.8995 4.07102e-06 0.9005 4.075e-06 0.9005 \
4.07502e-06 0.89975 4.079e-06 0.89975 4.07902e-06 0.901 4.083e-06 0.901 4.08302e-06 0.8985 4.087e-06 0.8985 4.08702e-06 0.89975 4.091e-06 0.89975 4.09102e-06 0.9005 4.095e-06 0.9005 4.09502e-06 0.8995 4.099e-06 0.8995 \
4.09902e-06 0.9 4.103e-06 0.9 4.10302e-06 0.90025 4.107e-06 0.90025 4.10702e-06 0.9015 4.111e-06 0.9015 4.11102e-06 0.899 4.115e-06 0.899 4.11502e-06 0.9 4.119e-06 0.9 4.11902e-06 0.901 4.123e-06 0.901 \
4.12302e-06 0.8985 4.127e-06 0.8985 4.12702e-06 0.9005 4.131e-06 0.9005 4.13102e-06 0.899 4.135e-06 0.899 4.13502e-06 0.8995 4.139e-06 0.8995 4.13902e-06 0.90025 4.143e-06 0.90025 4.14302e-06 0.9015 4.147e-06 0.9015 \
4.14702e-06 0.89975 4.151e-06 0.89975 4.15102e-06 0.8985 4.155e-06 0.8985 4.15502e-06 0.89975 4.159e-06 0.89975 4.15902e-06 0.9015 4.163e-06 0.9015 4.16302e-06 0.90025 4.167e-06 0.90025 4.16702e-06 0.9005 4.171e-06 0.9005 \
4.17102e-06 0.8995 4.175e-06 0.8995 4.17502e-06 0.901 4.179e-06 0.901 4.17902e-06 0.9 4.183e-06 0.9 4.18302e-06 0.899 4.187e-06 0.899 4.18702e-06 0.901 4.191e-06 0.901 4.19102e-06 0.899 4.195e-06 0.899 \
4.19502e-06 0.90025 4.199e-06 0.90025 4.19902e-06 0.9005 4.203e-06 0.9005 4.20302e-06 0.9 4.207e-06 0.9 4.20702e-06 0.8985 4.211e-06 0.8985 4.21102e-06 0.89975 4.215e-06 0.89975 4.21502e-06 0.8995 4.219e-06 0.8995 \
4.21902e-06 0.9015 4.223e-06 0.9015 4.22302e-06 0.8985 4.227e-06 0.8985 4.22702e-06 0.9015 4.231e-06 0.9015 4.23102e-06 0.9 4.235e-06 0.9 4.23502e-06 0.89975 4.239e-06 0.89975 4.23902e-06 0.8995 4.243e-06 0.8995 \
4.24302e-06 0.901 4.247e-06 0.901 4.24702e-06 0.899 4.251e-06 0.899 4.25102e-06 0.90025 4.255e-06 0.90025 4.25502e-06 0.9005 4.259e-06 0.9005 4.25902e-06 0.89975 4.263e-06 0.89975 4.26302e-06 0.9005 4.267e-06 0.9005 \
4.26702e-06 0.8995 4.271e-06 0.8995 4.27102e-06 0.901 4.275e-06 0.901 4.27502e-06 0.9 4.279e-06 0.9 4.27902e-06 0.8985 4.283e-06 0.8985 4.28302e-06 0.899 4.287e-06 0.899 4.28702e-06 0.9015 4.291e-06 0.9015 \
4.29102e-06 0.90025 4.295e-06 0.90025 4.29502e-06 0.9015 4.299e-06 0.9015 4.29902e-06 0.9 4.303e-06 0.9 4.30302e-06 0.89975 4.307e-06 0.89975 4.30702e-06 0.9005 4.311e-06 0.9005 4.31102e-06 0.8985 4.315e-06 0.8985 \
4.31502e-06 0.90025 4.319e-06 0.90025 4.31902e-06 0.901 4.323e-06 0.901 4.32302e-06 0.899 4.327e-06 0.899 4.32702e-06 0.8995 4.331e-06 0.8995 4.33102e-06 0.89975 4.335e-06 0.89975 4.33502e-06 0.899 4.339e-06 0.899 \
4.33902e-06 0.8995 4.343e-06 0.8995 4.34302e-06 0.90025 4.347e-06 0.90025 4.34702e-06 0.8985 4.351e-06 0.8985 4.35102e-06 0.901 4.355e-06 0.901 4.35502e-06 0.9005 4.359e-06 0.9005 4.35902e-06 0.9 4.363e-06 0.9 \
4.36302e-06 0.9015 4.367e-06 0.9015 4.36702e-06 0.9015 4.371e-06 0.9015 4.37102e-06 0.9005 4.375e-06 0.9005 4.37502e-06 0.901 4.379e-06 0.901 4.37902e-06 0.90025 4.383e-06 0.90025 4.38302e-06 0.9 4.387e-06 0.9 \
4.38702e-06 0.89975 4.391e-06 0.89975 4.39102e-06 0.8995 4.395e-06 0.8995 4.39502e-06 0.899 4.399e-06 0.899 4.39902e-06 0.8985 4.403e-06 0.8985 4.40302e-06 0.89975 4.407e-06 0.89975 4.40702e-06 0.8995 4.411e-06 0.8995 \
4.41102e-06 0.90025 4.415e-06 0.90025 4.41502e-06 0.8985 4.419e-06 0.8985 4.41902e-06 0.901 4.423e-06 0.901 4.42302e-06 0.9 4.427e-06 0.9 4.42702e-06 0.9015 4.431e-06 0.9015 4.43102e-06 0.9005 4.435e-06 0.9005 \
4.43502e-06 0.899 4.439e-06 0.899 4.43902e-06 0.9005 4.443e-06 0.9005 4.44302e-06 0.89975 4.447e-06 0.89975 4.44702e-06 0.899 4.451e-06 0.899 4.45102e-06 0.9 4.455e-06 0.9 4.45502e-06 0.901 4.459e-06 0.901 \
4.45902e-06 0.8985 4.463e-06 0.8985 4.46302e-06 0.90025 4.467e-06 0.90025 4.46702e-06 0.8995 4.471e-06 0.8995 4.47102e-06 0.9015 4.475e-06 0.9015 4.47502e-06 0.9 4.479e-06 0.9 4.47902e-06 0.901 4.483e-06 0.901 \
4.48302e-06 0.899 4.487e-06 0.899 4.48702e-06 0.89975 4.491e-06 0.89975 4.49102e-06 0.8995 4.495e-06 0.8995 4.49502e-06 0.9015 4.499e-06 0.9015 4.49902e-06 0.8985 4.503e-06 0.8985 4.50302e-06 0.9005 4.507e-06 0.9005 \
4.50702e-06 0.90025 4.511e-06 0.90025 4.51102e-06 0.8995 4.515e-06 0.8995 4.51502e-06 0.899 4.519e-06 0.899 4.51902e-06 0.89975 4.523e-06 0.89975 4.52302e-06 0.90025 4.527e-06 0.90025 4.52702e-06 0.9015 4.531e-06 0.9015 \
4.53102e-06 0.9 4.535e-06 0.9 4.53502e-06 0.9005 4.539e-06 0.9005 4.53902e-06 0.8985 4.543e-06 0.8985 4.54302e-06 0.901 4.547e-06 0.901 4.54702e-06 0.8985 4.551e-06 0.8985 4.55102e-06 0.9 4.555e-06 0.9 \
4.55502e-06 0.9005 4.559e-06 0.9005 4.55902e-06 0.901 4.563e-06 0.901 4.56302e-06 0.899 4.567e-06 0.899 4.56702e-06 0.89975 4.571e-06 0.89975 4.57102e-06 0.8995 4.575e-06 0.8995 4.57502e-06 0.90025 4.579e-06 0.90025 \
4.57902e-06 0.9015 4.583e-06 0.9015 4.58302e-06 0.9005 4.587e-06 0.9005 4.58702e-06 0.901 4.591e-06 0.901 4.59102e-06 0.90025 4.595e-06 0.90025 4.59502e-06 0.899 4.599e-06 0.899 4.59902e-06 0.9015 4.603e-06 0.9015 \
4.60302e-06 0.8985 4.607e-06 0.8985 4.60702e-06 0.89975 4.611e-06 0.89975 4.61102e-06 0.8995 4.615e-06 0.8995 4.61502e-06 0.9 4.619e-06 0.9 4.61902e-06 0.899 4.623e-06 0.899 4.62302e-06 0.901 4.627e-06 0.901 \
4.62702e-06 0.9 4.631e-06 0.9 4.63102e-06 0.90025 4.635e-06 0.90025 4.63502e-06 0.9015 4.639e-06 0.9015 4.63902e-06 0.8995 4.643e-06 0.8995 4.64302e-06 0.9005 4.647e-06 0.9005 4.64702e-06 0.89975 4.651e-06 0.89975 \
4.65102e-06 0.8985 4.655e-06 0.8985 4.65502e-06 0.8985 4.659e-06 0.8985 4.65902e-06 0.901 4.663e-06 0.901 4.66302e-06 0.90025 4.667e-06 0.90025 4.66702e-06 0.899 4.671e-06 0.899 4.67102e-06 0.9 4.675e-06 0.9 \
4.67502e-06 0.89975 4.679e-06 0.89975 4.67902e-06 0.8995 4.683e-06 0.8995 4.68302e-06 0.9005 4.687e-06 0.9005 4.68702e-06 0.9015 4.691e-06 0.9015 4.69102e-06 0.9 4.695e-06 0.9 4.69502e-06 0.899 4.699e-06 0.899 \
4.69902e-06 0.901 4.703e-06 0.901 4.70302e-06 0.89975 4.707e-06 0.89975 4.70702e-06 0.90025 4.711e-06 0.90025 4.71102e-06 0.9005 4.715e-06 0.9005 4.71502e-06 0.8995 4.719e-06 0.8995 4.71902e-06 0.8985 4.723e-06 0.8985 \
4.72302e-06 0.9015 4.727e-06 0.9015 4.72702e-06 0.1135 4.731e-06 0.1135 4.73102e-06 0.1115 4.735e-06 0.1115 4.73502e-06 0.112 4.739e-06 0.112 4.73902e-06 0.11275 4.743e-06 0.11275 4.74302e-06 0.114 4.747e-06 0.114 \
4.74702e-06 0.1125 4.751e-06 0.1125 4.75102e-06 0.113 4.755e-06 0.113 4.75502e-06 0.111 4.759e-06 0.111 4.75902e-06 0.11225 4.763e-06 0.11225 4.76302e-06 0.1135 4.767e-06 0.1135 4.76702e-06 0.113 4.771e-06 0.113 \
4.77102e-06 0.114 4.775e-06 0.114 4.77502e-06 0.111 4.779e-06 0.111 4.77902e-06 0.11225 4.783e-06 0.11225 4.78302e-06 0.11275 4.787e-06 0.11275 4.78702e-06 0.1115 4.791e-06 0.1115 4.79102e-06 0.112 4.795e-06 0.112 \
4.79502e-06 0.1125 4.799e-06 0.1125 4.79902e-06 0.113 4.803e-06 0.113 4.80302e-06 0.114 4.807e-06 0.114 4.80702e-06 0.11225 4.811e-06 0.11225 4.81102e-06 0.111 4.815e-06 0.111 4.81502e-06 0.112 4.819e-06 0.112 \
4.81902e-06 0.1125 4.823e-06 0.1125 4.82302e-06 0.1115 4.827e-06 0.1115 4.82702e-06 0.1135 4.831e-06 0.1135 4.83102e-06 0.11275 4.835e-06 0.11275 4.83502e-06 0.112 4.839e-06 0.112 4.83902e-06 0.1125 4.843e-06 0.1125 \
4.84302e-06 0.11225 4.847e-06 0.11225 4.84702e-06 0.11275 4.851e-06 0.11275 4.85102e-06 0.113 4.855e-06 0.113 4.85502e-06 0.1135 4.859e-06 0.1135 4.85902e-06 0.114 4.863e-06 0.114 4.86302e-06 0.111 4.867e-06 0.111 \
4.86702e-06 0.1115 4.871e-06 0.1115 4.87102e-06 0.112 4.875e-06 0.112 4.87502e-06 0.1115 4.879e-06 0.1115 4.87902e-06 0.1125 4.883e-06 0.1125 4.88302e-06 0.114 4.887e-06 0.114 4.88702e-06 0.111 4.891e-06 0.111 \
4.89102e-06 0.1135 4.895e-06 0.1135 4.89502e-06 0.11275 4.899e-06 0.11275 4.89902e-06 0.113 4.903e-06 0.113 4.90302e-06 0.11225 4.907e-06 0.11225 4.90702e-06 0.11275 4.911e-06 0.11275 4.91102e-06 0.1135 4.915e-06 0.1135 \
4.91502e-06 0.1125 4.919e-06 0.1125 4.91902e-06 0.112 4.923e-06 0.112 4.92302e-06 0.111 4.927e-06 0.111 4.92702e-06 0.113 4.931e-06 0.113 4.93102e-06 0.11225 4.935e-06 0.11225 4.93502e-06 0.114 4.939e-06 0.114 \
4.93902e-06 0.1115 4.943e-06 0.1115 4.94302e-06 0.11275 4.947e-06 0.11275 4.94702e-06 0.114 4.951e-06 0.114 4.95102e-06 0.112 4.955e-06 0.112 4.95502e-06 0.1135 4.959e-06 0.1135 4.95902e-06 0.1125 4.963e-06 0.1125 \
4.96302e-06 0.11225 4.967e-06 0.11225 4.96702e-06 0.111 4.971e-06 0.111 4.97102e-06 0.113 4.975e-06 0.113 4.97502e-06 0.1115 4.979e-06 0.1115 4.97902e-06 0.112 4.983e-06 0.112 4.98302e-06 0.1115 4.987e-06 0.1115 \
4.98702e-06 0.111 4.991e-06 0.111 4.99102e-06 0.113 4.995e-06 0.113 4.99502e-06 0.11225 4.999e-06 0.11225 4.99902e-06 0.114 5.003e-06 0.114 5.00302e-06 0.1125 5.007e-06 0.1125 5.00702e-06 0.11275 5.011e-06 0.11275 \
5.01102e-06 0.1135 5.015e-06 0.1135 5.01502e-06 0.1125 5.019e-06 0.1125 5.01902e-06 0.113 5.023e-06 0.113 5.02302e-06 0.11225 5.027e-06 0.11225 5.02702e-06 0.111 5.031e-06 0.111 5.03102e-06 0.1115 5.035e-06 0.1115 \
5.03502e-06 0.1135 5.039e-06 0.1135 5.03902e-06 0.112 5.043e-06 0.112 5.04302e-06 0.11275 5.047e-06 0.11275 5.04702e-06 0.114 5.051e-06 0.114 5.05102e-06 0.112 5.055e-06 0.112 5.05502e-06 0.113 5.059e-06 0.113 \
5.05902e-06 0.1125 5.063e-06 0.1125 5.06302e-06 0.11275 5.067e-06 0.11275 5.06702e-06 0.1115 5.071e-06 0.1115 5.07102e-06 0.11225 5.075e-06 0.11225 5.07502e-06 0.111 5.079e-06 0.111 5.07902e-06 0.114 5.083e-06 0.114 \
5.08302e-06 0.1135 5.087e-06 0.1135 5.08702e-06 0.114 5.091e-06 0.114 5.09102e-06 0.11275 5.095e-06 0.11275 5.09502e-06 0.1125 5.099e-06 0.1125 5.09902e-06 0.112 5.103e-06 0.112 5.10302e-06 0.11225 5.107e-06 0.11225 \
5.10702e-06 0.1135 5.111e-06 0.1135 5.11102e-06 0.1115 5.115e-06 0.1115 5.11502e-06 0.111 5.119e-06 0.111 5.11902e-06 0.113 5.123e-06 0.113 5.12302e-06 0.11225 5.127e-06 0.11225 5.12702e-06 0.1115 5.131e-06 0.1115 \
5.13102e-06 0.114 5.135e-06 0.114 5.13502e-06 0.1125 5.139e-06 0.1125 5.13902e-06 0.113 5.143e-06 0.113 5.14302e-06 0.11275 5.147e-06 0.11275 5.14702e-06 0.1135 5.151e-06 0.1135 5.15102e-06 0.111 5.155e-06 0.111 \
5.15502e-06 0.112 5.159e-06 0.112 5.15902e-06 0.111 5.163e-06 0.111 5.16302e-06 0.1125 5.167e-06 0.1125 5.16702e-06 0.11225 5.171e-06 0.11225 5.17102e-06 0.11275 5.175e-06 0.11275 5.17502e-06 0.113 5.179e-06 0.113 \
5.17902e-06 0.1135 5.183e-06 0.1135 5.18302e-06 0.1115 5.187e-06 0.1115 5.18702e-06 0.114 5.191e-06 0.114 5.19102e-06 0.112 5.195e-06 0.112 5.19502e-06 0.1125 5.199e-06 0.1125 5.19902e-06 0.112 5.203e-06 0.112 \
5.20302e-06 0.11275 5.207e-06 0.11275 5.20702e-06 0.1135 5.211e-06 0.1135 5.21102e-06 0.1115 5.215e-06 0.1115 5.21502e-06 0.11225 5.219e-06 0.11225 5.21902e-06 0.111 5.223e-06 0.111 5.22302e-06 0.114 5.227e-06 0.114 \
5.22702e-06 0.113 5.231e-06 0.113 5.23102e-06 0.11225 5.235e-06 0.11225 5.23502e-06 0.1125 5.239e-06 0.1125 5.23902e-06 0.1135 5.243e-06 0.1135 5.24302e-06 0.112 5.247e-06 0.112 5.24702e-06 0.1115 5.251e-06 0.1115 \
5.25102e-06 0.114 5.255e-06 0.114 5.25502e-06 0.111 5.259e-06 0.111 5.25902e-06 0.113 5.263e-06 0.113 5.26302e-06 0.11275 5.267e-06 0.11275 5.26702e-06 0.1135 5.271e-06 0.1135 5.27102e-06 0.113 5.275e-06 0.113 \
5.27502e-06 0.11275 5.279e-06 0.11275 5.27902e-06 0.1115 5.283e-06 0.1115 5.28302e-06 0.111 5.287e-06 0.111 5.28702e-06 0.112 5.291e-06 0.112 5.29102e-06 0.114 5.295e-06 0.114 5.29502e-06 0.11225 5.299e-06 0.11225 \
5.29902e-06 0.1125 5.303e-06 0.1125 5.30302e-06 0.113 5.307e-06 0.113 5.30702e-06 0.112 5.311e-06 0.112 5.31102e-06 0.11225 5.315e-06 0.11225 5.31502e-06 0.111 5.319e-06 0.111 5.31902e-06 0.1125 5.323e-06 0.1125 \
5.32302e-06 0.1135 5.327e-06 0.1135 5.32702e-06 0.114 5.331e-06 0.114 5.33102e-06 0.11275 5.335e-06 0.11275 5.33502e-06 0.1115 5.339e-06 0.1115 5.33902e-06 0.114 5.343e-06 0.114 5.34302e-06 0.1115 5.347e-06 0.1115 \
5.34702e-06 0.1125 5.351e-06 0.1125 5.35102e-06 0.1135 5.355e-06 0.1135 5.35502e-06 0.11225 5.359e-06 0.11225 5.35902e-06 0.111 5.363e-06 0.111 5.36302e-06 0.112 5.367e-06 0.112 5.36702e-06 0.113 5.371e-06 0.113 \
5.37102e-06 0.11275 5.375e-06 0.11275 5.37502e-06 0.112 5.379e-06 0.112 5.37902e-06 0.1135 5.383e-06 0.1135 5.38302e-06 0.1125 5.387e-06 0.1125 5.38702e-06 0.11225 5.391e-06 0.11225 5.39102e-06 0.1115 5.395e-06 0.1115 \
5.39502e-06 0.111 5.399e-06 0.111 5.39902e-06 0.113 5.403e-06 0.113 5.40302e-06 0.114 5.407e-06 0.114 5.40702e-06 0.11275 5.411e-06 0.11275 5.41102e-06 0.11275 5.415e-06 0.11275 5.41502e-06 0.1115 5.419e-06 0.1115 \
5.41902e-06 0.114 5.423e-06 0.114 5.42302e-06 0.112 5.427e-06 0.112 5.42702e-06 0.1125 5.431e-06 0.1125 5.43102e-06 0.11225 5.435e-06 0.11225 5.43502e-06 0.1135 5.439e-06 0.1135 5.43902e-06 0.113 5.443e-06 0.113 \
5.44302e-06 0.111 5.447e-06 0.111 5.44702e-06 0.112 5.451e-06 0.112 5.45102e-06 0.11275 5.455e-06 0.11275 5.45502e-06 0.111 5.459e-06 0.111 5.45902e-06 0.113 5.463e-06 0.113 5.46302e-06 0.1135 5.467e-06 0.1135 \
5.46702e-06 0.1115 5.471e-06 0.1115 5.47102e-06 0.11225 5.475e-06 0.11225 5.47502e-06 0.1125 5.479e-06 0.1125 5.47902e-06 0.114 5.483e-06 0.114 5.48302e-06 0.11225 5.487e-06 0.11225 5.48702e-06 0.1125 5.491e-06 0.1125 \
5.49102e-06 0.111 5.495e-06 0.111 5.49502e-06 0.1135 5.499e-06 0.1135 5.49902e-06 0.114 5.503e-06 0.114 5.50302e-06 0.11275 5.507e-06 0.11275 5.50702e-06 0.112 5.511e-06 0.112 5.51102e-06 0.1115 5.515e-06 0.1115 \
5.51502e-06 0.113 5.519e-06 0.113 5.51902e-06 0.1125 5.523e-06 0.1125 5.52302e-06 0.11275 5.527e-06 0.11275 5.52702e-06 0.111 5.531e-06 0.111 5.53102e-06 0.113 5.535e-06 0.113 5.53502e-06 0.11225 5.539e-06 0.11225 \
5.53902e-06 0.1135 5.543e-06 0.1135 5.54302e-06 0.114 5.547e-06 0.114 5.54702e-06 0.112 5.551e-06 0.112 5.55102e-06 0.1115 5.555e-06 0.1115 5.55502e-06 0.1125 5.559e-06 0.1125 5.55902e-06 0.1135 5.563e-06 0.1135 \
5.56302e-06 0.112 5.567e-06 0.112 5.56702e-06 0.111 5.571e-06 0.111 5.57102e-06 0.11275 5.575e-06 0.11275 5.57502e-06 0.113 5.579e-06 0.113 5.57902e-06 0.11225 5.583e-06 0.11225 5.58302e-06 0.1115 5.587e-06 0.1115 \
5.58702e-06 0.114 5.591e-06 0.114 5.59102e-06 0.111 5.595e-06 0.111 5.59502e-06 0.1115 5.599e-06 0.1115 5.59902e-06 0.1135 5.603e-06 0.1135 5.60302e-06 0.11225 5.607e-06 0.11225 5.60702e-06 0.1125 5.611e-06 0.1125 \
5.61102e-06 0.112 5.615e-06 0.112 5.61502e-06 0.114 5.619e-06 0.114 5.61902e-06 0.113 5.623e-06 0.113 5.62302e-06 0.11275 5.627e-06 0.11275 5.62702e-06 0.111 5.631e-06 0.111 5.63102e-06 0.11275 5.635e-06 0.11275 \
5.63502e-06 0.1115 5.639e-06 0.1115 5.63902e-06 0.1135 5.643e-06 0.1135 5.64302e-06 0.1125 5.647e-06 0.1125 5.64702e-06 0.112 5.651e-06 0.112 5.65102e-06 0.11225 5.655e-06 0.11225 5.65502e-06 0.113 5.659e-06 0.113 \
5.65902e-06 0.114 5.663e-06 0.114 5.66302e-06 0.114 5.667e-06 0.114 5.66702e-06 0.1125 5.671e-06 0.1125 5.67102e-06 0.112 5.675e-06 0.112 5.67502e-06 0.113 5.679e-06 0.113 5.67902e-06 0.11275 5.683e-06 0.11275 \
5.68302e-06 0.1135 5.687e-06 0.1135 5.68702e-06 0.11225 5.691e-06 0.11225 5.69102e-06 0.1115 5.695e-06 0.1115 5.69502e-06 0.111 5.699e-06 0.111 5.69902e-06 0.114 5.703e-06 0.114 5.70302e-06 0.1135 5.707e-06 0.1135 \
5.70702e-06 0.111 5.711e-06 0.111 5.71102e-06 0.1125 5.715e-06 0.1125 5.71502e-06 0.112 5.719e-06 0.112 5.71902e-06 0.11225 5.723e-06 0.11225 5.72302e-06 0.11275 5.727e-06 0.11275 5.72702e-06 0.113 5.731e-06 0.113 \
5.73102e-06 0.1115 5.735e-06 0.1115 5.73502e-06 0.112 5.739e-06 0.112 5.73902e-06 0.114 5.743e-06 0.114 5.74302e-06 0.1125 5.747e-06 0.1125 5.74702e-06 0.1115 5.751e-06 0.1115 5.75102e-06 0.11275 5.755e-06 0.11275 \
5.75502e-06 0.1135 5.759e-06 0.1135 5.75902e-06 0.11225 5.763e-06 0.11225 5.76302e-06 0.111 5.767e-06 0.111 5.76702e-06 0.113 5.771e-06 0.113 5.77102e-06 0.1135 5.775e-06 0.1135 5.77502e-06 0.11275 5.779e-06 0.11275 \
5.77902e-06 0.113 5.783e-06 0.113 5.78302e-06 0.11225 5.787e-06 0.11225 5.78702e-06 0.1115 5.791e-06 0.1115 5.79102e-06 0.114 5.795e-06 0.114 5.79502e-06 0.111 5.799e-06 0.111 5.79902e-06 0.1125 5.803e-06 0.1125 \
5.80302e-06 0.112 5.807e-06 0.112 5.80702e-06 0.11225 5.811e-06 0.11225 5.81102e-06 0.1125 5.815e-06 0.1125 5.81502e-06 0.1135 5.819e-06 0.1135 5.81902e-06 0.11275 5.823e-06 0.11275 5.82302e-06 0.112 5.827e-06 0.112 \
5.82702e-06 0.114 5.831e-06 0.114 5.83102e-06 0.111 5.835e-06 0.111 5.83502e-06 0.1115 5.839e-06 0.1115 5.83902e-06 0.113 5.843e-06 0.113 5.84302e-06 0.114 5.847e-06 0.114 5.84702e-06 0.113 5.851e-06 0.113 \
5.85102e-06 0.11275 5.855e-06 0.11275 5.85502e-06 0.1115 5.859e-06 0.1115 5.85902e-06 0.1135 5.863e-06 0.1135 5.86302e-06 0.111 5.867e-06 0.111 5.86702e-06 0.112 5.871e-06 0.112 5.87102e-06 0.1125 5.875e-06 0.1125 \
5.87502e-06 0.11225 5.879e-06 0.11225 5.87902e-06 0.113 5.883e-06 0.113 5.88302e-06 0.112 5.887e-06 0.112 5.88702e-06 0.111 5.891e-06 0.111 5.89102e-06 0.1115 5.895e-06 0.1115 5.89502e-06 0.11275 5.899e-06 0.11275 \
5.89902e-06 0.114 5.903e-06 0.114 5.90302e-06 0.11225 5.907e-06 0.11225 5.90702e-06 0.1135 5.911e-06 0.1135 5.91102e-06 0.1125 5.915e-06 0.1125 5.91502e-06 0.1125 5.919e-06 0.1125 5.91902e-06 0.112 5.923e-06 0.112 \
5.92302e-06 0.1115 5.927e-06 0.1115 5.92702e-06 0.111 5.931e-06 0.111 5.93102e-06 0.114 5.935e-06 0.114 5.93502e-06 0.11275 5.939e-06 0.11275 5.93902e-06 0.1135 5.943e-06 0.1135 5.94302e-06 0.113 5.947e-06 0.113 \
5.94702e-06 0.11225 5.951e-06 0.11225 5.95102e-06 0.11225 5.955e-06 0.11225 5.95502e-06 0.1135 5.959e-06 0.1135 5.95902e-06 0.113 5.963e-06 0.113 5.96302e-06 0.1125 5.967e-06 0.1125 5.96702e-06 0.11275 5.971e-06 0.11275 \
5.97102e-06 0.1115 5.975e-06 0.1115 5.97502e-06 0.112 5.979e-06 0.112 5.97902e-06 0.111 5.983e-06 0.111 5.98302e-06 0.114 5.987e-06 0.114 5.98702e-06 0.1135 5.991e-06 0.1135 5.99102e-06 0.11275 5.995e-06 0.11275 \
5.99502e-06 0.113 5.999e-06 0.113 5.99902e-06 0.112 6.003e-06 0.112 6.00302e-06 0.114 6.007e-06 0.114 6.00702e-06 0.111 6.011e-06 0.111 6.01102e-06 0.11225 6.015e-06 0.11225 6.01502e-06 0.1115 6.019e-06 0.1115 \
6.01902e-06 0.1125 6.023e-06 0.1125 6.02302e-06 0.1125 6.027e-06 0.1125 6.02702e-06 0.11275 6.031e-06 0.11275 6.03102e-06 0.11225 6.035e-06 0.11225 6.03502e-06 0.113 6.039e-06 0.113 6.03902e-06 0.112 6.043e-06 0.112 \
6.04302e-06 0.114 6.047e-06 0.114 6.04702e-06 0.1135 6.051e-06 0.1135 6.05102e-06 0.1115 6.055e-06 0.1115 6.05502e-06 0.111 6.059e-06 0.111 6.05902e-06 0.1135 6.063e-06 0.1135 6.06302e-06 0.1115 6.067e-06 0.1115 \
6.06702e-06 0.11225 6.071e-06 0.11225 6.07102e-06 0.1125 6.075e-06 0.1125 6.07502e-06 0.114 6.079e-06 0.114 6.07902e-06 0.112 6.083e-06 0.112 6.08302e-06 0.11275 6.087e-06 0.11275 6.08702e-06 0.113 6.091e-06 0.113 \
6.09102e-06 0.111 6.095e-06 0.111 6.09502e-06 0.1125 6.099e-06 0.1125 6.09902e-06 0.113 6.103e-06 0.113 6.10302e-06 0.112 6.107e-06 0.112 6.10702e-06 0.114 6.111e-06 0.114 6.11102e-06 0.11275 6.115e-06 0.11275 \
6.11502e-06 0.1115 6.119e-06 0.1115 6.11902e-06 0.111 6.123e-06 0.111 6.12302e-06 0.11225 6.127e-06 0.11225 6.12702e-06 0.1135 6.131e-06 0.1135 6.13102e-06 0.1115 6.135e-06 0.1115 6.13502e-06 0.1125 6.139e-06 0.1125 \
6.13902e-06 0.11275 6.143e-06 0.11275 6.14302e-06 0.111 6.147e-06 0.111 6.14702e-06 0.11225 6.151e-06 0.11225 6.15102e-06 0.112 6.155e-06 0.112 6.15502e-06 0.113 6.159e-06 0.113 6.15902e-06 0.114 6.163e-06 0.114 \
6.16302e-06 0.1135 6.167e-06 0.1135 6.16702e-06 0.113 6.171e-06 0.113 6.17102e-06 0.1125 6.175e-06 0.1125 6.17502e-06 0.11275 6.179e-06 0.11275 6.17902e-06 0.114 6.183e-06 0.114 6.18302e-06 0.112 6.187e-06 0.112 \
6.18702e-06 0.11225 6.191e-06 0.11225 6.19102e-06 0.111 6.195e-06 0.111 6.19502e-06 0.1135 6.199e-06 0.1135 6.19902e-06 0.1115 6.203e-06 0.1115 6.20302e-06 0.111 6.207e-06 0.111 6.20702e-06 0.1115 6.211e-06 0.1115 \
6.21102e-06 0.113 6.215e-06 0.113 6.21502e-06 0.114 6.219e-06 0.114 6.21902e-06 0.112 6.223e-06 0.112 6.22302e-06 0.11275 6.227e-06 0.11275 6.22702e-06 0.1135 6.231e-06 0.1135 6.23102e-06 0.11225 6.235e-06 0.11225 \
6.23502e-06 0.1125 6.239e-06 0.1125 6.23902e-06 0.1115 6.243e-06 0.1115 6.24302e-06 0.112 6.247e-06 0.112 6.24702e-06 0.11225 6.251e-06 0.11225 6.25102e-06 0.114 6.255e-06 0.114 6.25502e-06 0.11275 6.259e-06 0.11275 \
6.25902e-06 0.1135 6.263e-06 0.1135 6.26302e-06 0.1125 6.267e-06 0.1125 6.26702e-06 0.113 6.271e-06 0.113 6.27102e-06 0.111 6.275e-06 0.111 6.27502e-06 0.11225 6.279e-06 0.11225 6.27902e-06 0.1135 6.283e-06 0.1135 \
6.28302e-06 0.1115 6.287e-06 0.1115 6.28702e-06 0.1125 6.291e-06 0.1125 6.29102e-06 0.11275 6.295e-06 0.11275 6.29502e-06 0.112 6.299e-06 0.112 6.29902e-06 0.113 6.303e-06 0.113 6.30302e-06 0.114 6.307e-06 0.114 \
6.30702e-06 0.111 6.311e-06 0.111 6.31102e-06 0.1135 6.315e-06 0.1135 6.31502e-06 0.11275 6.319e-06 0.11275 6.31902e-06 0.1115 6.323e-06 0.1115 6.32302e-06 0.114 6.327e-06 0.114 6.32702e-06 0.111 6.331e-06 0.111 \
6.33102e-06 0.113 6.335e-06 0.113 6.33502e-06 0.11225 6.339e-06 0.11225 6.33902e-06 0.112 6.343e-06 0.112 6.34302e-06 0.1125 6.347e-06 0.1125 6.34702e-06 0.113 6.351e-06 0.113 6.35102e-06 0.1115 6.355e-06 0.1115 \
6.35502e-06 0.112 6.359e-06 0.112 6.35902e-06 0.114 6.363e-06 0.114 6.36302e-06 0.1135 6.367e-06 0.1135 6.36702e-06 0.11275 6.371e-06 0.11275 6.37102e-06 0.11225 6.375e-06 0.11225 6.37502e-06 0.111 6.379e-06 0.111 \
6.37902e-06 0.1125 6.383e-06 0.1125 6.38302e-06 0.1125 6.387e-06 0.1125 6.38702e-06 0.114 6.391e-06 0.114 6.39102e-06 0.113 6.395e-06 0.113 6.39502e-06 0.111 6.399e-06 0.111 6.39902e-06 0.1135 6.403e-06 0.1135 \
6.40302e-06 0.1115 6.407e-06 0.1115 6.40702e-06 0.11225 6.411e-06 0.11225 6.41102e-06 0.11275 6.415e-06 0.11275 6.41502e-06 0.112 6.419e-06 0.112 6.41902e-06 0.1125 6.423e-06 0.1125 6.42302e-06 0.111 6.427e-06 0.111 \
6.42702e-06 0.114 6.431e-06 0.114 6.43102e-06 0.11275 6.435e-06 0.11275 6.43502e-06 0.1115 6.439e-06 0.1115 6.43902e-06 0.1135 6.443e-06 0.1135 6.44302e-06 0.11225 6.447e-06 0.11225 6.44702e-06 0.113 6.451e-06 0.113 \
6.45102e-06 0.112 6.455e-06 0.112 6.45502e-06 0.11225 6.459e-06 0.11225 6.45902e-06 0.111 6.463e-06 0.111 6.46302e-06 0.113 6.467e-06 0.113 6.46702e-06 0.11275 6.471e-06 0.11275 6.47102e-06 0.1135 6.475e-06 0.1135 \
6.47502e-06 0.1115 6.479e-06 0.1115 6.47902e-06 0.1125 6.483e-06 0.1125 6.48302e-06 0.114 6.487e-06 0.114 6.48702e-06 0.112 6.491e-06 0.112 6.49102e-06 0.114 6.495e-06 0.114 6.49502e-06 0.1115 6.499e-06 0.1115 \
6.49902e-06 0.1135 6.503e-06 0.1135 6.50302e-06 0.1125 6.507e-06 0.1125 6.50702e-06 0.112 6.511e-06 0.112 6.51102e-06 0.11225 6.515e-06 0.11225 6.51502e-06 0.113 6.519e-06 0.113 6.51902e-06 0.111 6.523e-06 0.111 \
6.52302e-06 0.11275 6.527e-06 0.11275 6.52702e-06 0.11275 6.531e-06 0.11275 6.53102e-06 0.1125 6.535e-06 0.1125 6.53502e-06 0.112 6.539e-06 0.112 6.53902e-06 0.114 6.543e-06 0.114 6.54302e-06 0.111 6.547e-06 0.111 \
6.54702e-06 0.11225 6.551e-06 0.11225 6.55102e-06 0.1135 6.555e-06 0.1135 6.55502e-06 0.113 6.559e-06 0.113 6.55902e-06 0.1115 6.563e-06 0.1115 6.56302e-06 0.11275 6.567e-06 0.11275 6.56702e-06 0.112 6.571e-06 0.112 \
6.57102e-06 0.11225 6.575e-06 0.11225 6.57502e-06 0.111 6.579e-06 0.111 6.57902e-06 0.113 6.583e-06 0.113 6.58302e-06 0.1125 6.587e-06 0.1125 6.58702e-06 0.114 6.591e-06 0.114 6.59102e-06 0.1135 6.595e-06 0.1135 \
6.59502e-06 0.1115 6.599e-06 0.1115 6.59902e-06 0.11275 6.603e-06 0.11275 6.60302e-06 0.11225 6.607e-06 0.11225 6.60702e-06 0.114 6.611e-06 0.114 6.61102e-06 0.112 6.615e-06 0.112 6.61502e-06 0.113 6.619e-06 0.113 \
6.61902e-06 0.1135 6.623e-06 0.1135 6.62302e-06 0.1125 6.627e-06 0.1125 6.62702e-06 0.111 6.631e-06 0.111 6.63102e-06 0.1115 6.635e-06 0.1115 6.63502e-06 0.1135 6.639e-06 0.1135 6.63902e-06 0.1125 6.643e-06 0.1125 \
6.64302e-06 0.113 6.647e-06 0.113 6.64702e-06 0.1115 6.651e-06 0.1115 6.65102e-06 0.114 6.655e-06 0.114 6.65502e-06 0.11275 6.659e-06 0.11275 6.65902e-06 0.111 6.663e-06 0.111 6.66302e-06 0.112 6.667e-06 0.112 \
6.66702e-06 0.11225 6.671e-06 0.11225 6.67102e-06 0.11225 6.675e-06 0.11225 6.67502e-06 0.1135 6.679e-06 0.1135 6.67902e-06 0.114 6.683e-06 0.114 6.68302e-06 0.111 6.687e-06 0.111 6.68702e-06 0.1115 6.691e-06 0.1115 \
6.69102e-06 0.113 6.695e-06 0.113 6.69502e-06 0.11275 6.699e-06 0.11275 6.69902e-06 0.112 6.703e-06 0.112 6.70302e-06 0.1125 6.707e-06 0.1125 6.70702e-06 0.111 6.711e-06 0.111 6.71102e-06 0.112 6.715e-06 0.112 \
6.71502e-06 0.1125 6.719e-06 0.1125 6.71902e-06 0.113 6.723e-06 0.113 6.72302e-06 0.11275 6.727e-06 0.11275 6.72702e-06 0.11225 6.731e-06 0.11225 6.73102e-06 0.1135 6.735e-06 0.1135 6.73502e-06 0.114 6.739e-06 0.114 \
6.73902e-06 0.1115 6.743e-06 0.1115 6.74302e-06 0.11225 6.747e-06 0.11225 6.74702e-06 0.113 6.751e-06 0.113 6.75102e-06 0.11275 6.755e-06 0.11275 6.75502e-06 0.1125 6.759e-06 0.1125 6.75902e-06 0.112 6.763e-06 0.112 \
6.76302e-06 0.1135 6.767e-06 0.1135 6.76702e-06 0.1115 6.771e-06 0.1115 6.77102e-06 0.111 6.775e-06 0.111 6.77502e-06 0.114 6.779e-06 0.114 6.77902e-06 0.11275 6.783e-06 0.11275 6.78302e-06 0.1115 6.787e-06 0.1115 \
6.78702e-06 0.11225 6.791e-06 0.11225 6.79102e-06 0.113 6.795e-06 0.113 6.79502e-06 0.1135 6.799e-06 0.1135 6.79902e-06 0.111 6.803e-06 0.111 6.80302e-06 0.1125 6.807e-06 0.1125 6.80702e-06 0.112 6.811e-06 0.112 \
6.81102e-06 0.114 6.815e-06 0.114 6.81502e-06 0.11275 6.819e-06 0.11275 6.81902e-06 0.112 6.823e-06 0.112 6.82302e-06 0.1115 6.827e-06 0.1115 6.82702e-06 0.111 6.831e-06 0.111 6.83102e-06 0.1125 6.835e-06 0.1125 \
6.83502e-06 0.11225 6.839e-06 0.11225 6.83902e-06 0.1135 6.843e-06 0.1135 6.84302e-06 0.114 6.847e-06 0.114 6.84702e-06 0.113 6.851e-06 0.113 6.85102e-06 0.114 6.855e-06 0.114 6.85502e-06 0.1135 6.859e-06 0.1135 \
6.85902e-06 0.1115 6.863e-06 0.1115 6.86302e-06 0.11225 6.867e-06 0.11225 6.86702e-06 0.113 6.871e-06 0.113 6.87102e-06 0.1125 6.875e-06 0.1125 6.87502e-06 0.112 6.879e-06 0.112 6.87902e-06 0.111 6.883e-06 0.111 \
6.88302e-06 0.11275 6.887e-06 0.11275 6.88702e-06 0.114 6.891e-06 0.114 6.89102e-06 0.1125 6.895e-06 0.1125 6.89502e-06 0.113 6.899e-06 0.113 6.89902e-06 0.1135 6.903e-06 0.1135 6.90302e-06 0.11225 6.907e-06 0.11225 \
6.90702e-06 0.112 6.911e-06 0.112 6.91102e-06 0.11275 6.915e-06 0.11275 6.91502e-06 0.111 6.919e-06 0.111 6.91902e-06 0.1115 6.923e-06 0.1115 6.92302e-06 0.113 6.927e-06 0.113 6.92702e-06 0.1125 6.931e-06 0.1125 \
6.93102e-06 0.114 6.935e-06 0.114 6.93502e-06 0.1115 6.939e-06 0.1115 6.93902e-06 0.11275 6.943e-06 0.11275 6.94302e-06 0.112 6.947e-06 0.112 6.94702e-06 0.1135 6.951e-06 0.1135 6.95102e-06 0.111 6.955e-06 0.111 \
6.95502e-06 0.11225 6.959e-06 0.11225 6.95902e-06 0.114 6.963e-06 0.114 6.96302e-06 0.11225 6.967e-06 0.11225 6.96702e-06 0.111 6.971e-06 0.111 6.97102e-06 0.112 6.975e-06 0.112 6.97502e-06 0.1135 6.979e-06 0.1135 \
6.97902e-06 0.1125 6.983e-06 0.1125 6.98302e-06 0.113 6.987e-06 0.113 6.98702e-06 0.1115 6.991e-06 0.1115 6.99102e-06 0.11275 6.995e-06 0.11275 6.99502e-06 0.1125 6.999e-06 0.1125 6.99902e-06 0.1115 7.003e-06 0.1115 \
7.00302e-06 0.11225 7.007e-06 0.11225 7.00702e-06 0.1135 7.011e-06 0.1135 7.01102e-06 0.11275 7.015e-06 0.11275 7.01502e-06 0.113 7.019e-06 0.113 7.01902e-06 0.112 7.023e-06 0.112 7.02302e-06 0.114 7.027e-06 0.114 \
7.02702e-06 0.111 7.031e-06 0.111 7.03102e-06 0.1135 7.035e-06 0.1135 7.03502e-06 0.112 7.039e-06 0.112 7.03902e-06 0.11225 7.043e-06 0.11225 7.04302e-06 0.113 7.047e-06 0.113 7.04702e-06 0.114 7.051e-06 0.114 \
7.05102e-06 0.1125 7.055e-06 0.1125 7.05502e-06 0.11275 7.059e-06 0.11275 7.05902e-06 0.1115 7.063e-06 0.1115 7.06302e-06 0.111 7.067e-06 0.111 7.06702e-06 0.1115 7.071e-06 0.1115 7.07102e-06 0.111 7.075e-06 0.111 \
7.07502e-06 0.113 7.079e-06 0.113 7.07902e-06 0.1125 7.083e-06 0.1125 7.08302e-06 0.112 7.087e-06 0.112 7.08702e-06 0.11275 7.091e-06 0.11275 7.09102e-06 0.11225 7.095e-06 0.11225 7.09502e-06 0.1135 7.099e-06 0.1135 \
7.09902e-06 0.114 7.103e-06 0.114 7.10302e-06 0.114 7.107e-06 0.114 7.10702e-06 0.11225 7.111e-06 0.11225 7.11102e-06 0.1115 7.115e-06 0.1115 7.11502e-06 0.1125 7.119e-06 0.1125 7.11902e-06 0.11275 7.123e-06 0.11275 \
7.12302e-06 0.1135 7.127e-06 0.1135 7.12702e-06 0.113 7.131e-06 0.113 7.13102e-06 0.112 7.135e-06 0.112 7.13502e-06 0.111 7.139e-06 0.111 7.13902e-06 0.113 7.143e-06 0.113 7.14302e-06 0.11225 7.147e-06 0.11225 \
7.14702e-06 0.111 7.151e-06 0.111 7.15102e-06 0.1115 7.155e-06 0.1115 7.15502e-06 0.114 7.159e-06 0.114 7.15902e-06 0.1135 7.163e-06 0.1135 7.16302e-06 0.1125 7.167e-06 0.1125 7.16702e-06 0.11275 7.171e-06 0.11275 \
7.17102e-06 0.112 7.175e-06 0.112 7.17502e-06 0.1135 7.179e-06 0.1135 7.17902e-06 0.1125 7.183e-06 0.1125 7.18302e-06 0.11275 7.187e-06 0.11275 7.18702e-06 0.113 7.191e-06 0.113 7.19102e-06 0.11225 7.195e-06 0.11225 \
7.19502e-06 0.1115 7.199e-06 0.1115 7.19902e-06 0.112 7.203e-06 0.112 7.20302e-06 0.114 7.207e-06 0.114 7.20702e-06 0.111 7.211e-06 0.111 7.21102e-06 0.1125 7.215e-06 0.1125 7.21502e-06 0.1115 7.219e-06 0.1115 \
7.21902e-06 0.112 7.223e-06 0.112 7.22302e-06 0.11275 7.227e-06 0.11275 7.22702e-06 0.114 7.231e-06 0.114 7.23102e-06 0.11225 7.235e-06 0.11225 7.23502e-06 0.1135 7.239e-06 0.1135 7.23902e-06 0.113 7.243e-06 0.113 \
7.24302e-06 0.111 7.247e-06 0.111 7.24702e-06 0.11225 7.251e-06 0.11225 7.25102e-06 0.114 7.255e-06 0.114 7.25502e-06 0.1115 7.259e-06 0.1115 7.25902e-06 0.1135 7.263e-06 0.1135 7.26302e-06 0.11275 7.267e-06 0.11275 \
7.26702e-06 0.1125 7.271e-06 0.1125 7.27102e-06 0.113 7.275e-06 0.113 7.27502e-06 0.111 7.279e-06 0.111 7.27902e-06 0.112 7.283e-06 0.112 7.28302e-06 0.1115 7.287e-06 0.1115 7.28702e-06 0.11275 7.291e-06 0.11275 \
7.29102e-06 0.114 7.295e-06 0.114 7.29502e-06 0.113 7.299e-06 0.113 7.29902e-06 0.1135 7.303e-06 0.1135 7.30302e-06 0.11225 7.307e-06 0.11225 7.30702e-06 0.111 7.311e-06 0.111 7.31102e-06 0.1125 7.315e-06 0.1125 \
7.31502e-06 0.112 7.319e-06 0.112 7.31902e-06 0.112 7.323e-06 0.112 7.32302e-06 0.1115 7.327e-06 0.1115 7.32702e-06 0.11275 7.331e-06 0.11275 7.33102e-06 0.1135 7.335e-06 0.1135 7.33502e-06 0.114 7.339e-06 0.114 \
7.33902e-06 0.113 7.343e-06 0.113 7.34302e-06 0.11225 7.347e-06 0.11225 7.34702e-06 0.111 7.351e-06 0.111 7.35102e-06 0.1125 7.355e-06 0.1125 7.35502e-06 0.113 7.359e-06 0.113 7.35902e-06 0.1135 7.363e-06 0.1135 \
7.36302e-06 0.11275 7.367e-06 0.11275 7.36702e-06 0.11225 7.371e-06 0.11225 7.37102e-06 0.111 7.375e-06 0.111 7.37502e-06 0.112 7.379e-06 0.112 7.37902e-06 0.1125 7.383e-06 0.1125 7.38302e-06 0.1115 7.387e-06 0.1115 \
7.38702e-06 0.114 7.391e-06 0.114 7.39102e-06 0.114 7.395e-06 0.114 7.39502e-06 0.11225 7.399e-06 0.11225 7.39902e-06 0.1125 7.403e-06 0.1125 7.40302e-06 0.112 7.407e-06 0.112 7.40702e-06 0.1115 7.411e-06 0.1115 \
7.41102e-06 0.111 7.415e-06 0.111 7.41502e-06 0.1135 7.419e-06 0.1135 7.41902e-06 0.113 7.423e-06 0.113 7.42302e-06 0.11275 7.427e-06 0.11275 7.42702e-06 0.11225 7.431e-06 0.11225 7.43102e-06 0.1135 7.435e-06 0.1135 \
7.43502e-06 0.114 7.439e-06 0.114 7.43902e-06 0.1125 7.443e-06 0.1125 7.44302e-06 0.113 7.447e-06 0.113 7.44702e-06 0.112 7.451e-06 0.112 7.45102e-06 0.11275 7.455e-06 0.11275 7.45502e-06 0.1115 7.459e-06 0.1115 \
7.45902e-06 0.111 7.463e-06 0.111 7.46302e-06 0.1135 7.467e-06 0.1135 7.46702e-06 0.11275 7.471e-06 0.11275 7.47102e-06 0.1125 7.475e-06 0.1125 7.47502e-06 0.1115 7.479e-06 0.1115 7.47902e-06 0.112 7.483e-06 0.112 \
7.48302e-06 0.114 7.487e-06 0.114 7.48702e-06 0.113 7.491e-06 0.113 7.49102e-06 0.11225 7.495e-06 0.11225 7.49502e-06 0.111 7.499e-06 0.111 7.49902e-06 0.114 7.503e-06 0.114 7.50302e-06 0.1125 7.507e-06 0.1125 \
7.50702e-06 0.1115 7.511e-06 0.1115 7.51102e-06 0.111 7.515e-06 0.111 7.51502e-06 0.1135 7.519e-06 0.1135 7.51902e-06 0.11225 7.523e-06 0.11225 7.52302e-06 0.112 7.527e-06 0.112 7.52702e-06 0.113 7.531e-06 0.113 \
7.53102e-06 0.11275 7.535e-06 0.11275 7.53502e-06 0.113 7.539e-06 0.113 7.53902e-06 0.112 7.543e-06 0.112 7.54302e-06 0.11225 7.547e-06 0.11225 7.54702e-06 0.111 7.551e-06 0.111 7.55102e-06 0.114 7.555e-06 0.114 \
7.55502e-06 0.1125 7.559e-06 0.1125 7.55902e-06 0.11275 7.563e-06 0.11275 7.56302e-06 0.1135 7.567e-06 0.1135 7.56702e-06 0.1115 7.571e-06 0.1115 7.57102e-06 0.111 7.575e-06 0.111 7.57502e-06 0.1125 7.579e-06 0.1125 \
7.57902e-06 0.11225 7.583e-06 0.11225 7.58302e-06 0.114 7.587e-06 0.114 7.58702e-06 0.11275 7.591e-06 0.11275 7.59102e-06 0.112 7.595e-06 0.112 7.59502e-06 0.1115 7.599e-06 0.1115 7.59902e-06 0.1135 7.603e-06 0.1135 \
7.60302e-06 0.113 7.607e-06 0.113 7.60702e-06 0.1125 7.611e-06 0.1125 7.61102e-06 0.112 7.615e-06 0.112 7.61502e-06 0.11275 7.619e-06 0.11275 7.61902e-06 0.11225 7.623e-06 0.11225 7.62302e-06 0.1135 7.627e-06 0.1135 \
7.62702e-06 0.113 7.631e-06 0.113 7.63102e-06 0.1115 7.635e-06 0.1115 7.63502e-06 0.111 7.639e-06 0.111 7.63902e-06 0.114 7.643e-06 0.114 7.64302e-06 0.114 7.647e-06 0.114 7.64702e-06 0.1115 7.651e-06 0.1115 \
7.65102e-06 0.112 7.655e-06 0.112 7.65502e-06 0.11275 7.659e-06 0.11275 7.65902e-06 0.1125 7.663e-06 0.1125 7.66302e-06 0.113 7.667e-06 0.113 7.66702e-06 0.11225 7.671e-06 0.11225 7.67102e-06 0.1135 7.675e-06 0.1135 \
7.67502e-06 0.111 7.679e-06 0.111 7.67902e-06 0.113 7.683e-06 0.113 7.68302e-06 0.1115 7.687e-06 0.1115 7.68702e-06 0.111 7.691e-06 0.111 7.69102e-06 0.1135 7.695e-06 0.1135 7.69502e-06 0.1125 7.699e-06 0.1125 \
7.69902e-06 0.112 7.703e-06 0.112 7.70302e-06 0.11225 7.707e-06 0.11225 7.70702e-06 0.114 7.711e-06 0.114 7.71102e-06 0.11275 7.715e-06 0.11275 7.71502e-06 0.1135 7.719e-06 0.1135 7.71902e-06 0.11225 7.723e-06 0.11225 \
7.72302e-06 0.114 7.727e-06 0.114 7.72702e-06 0.112 7.731e-06 0.112 7.73102e-06 0.11275 7.735e-06 0.11275 7.73502e-06 0.113 7.739e-06 0.113 7.73902e-06 0.111 7.743e-06 0.111 7.74302e-06 0.1115 7.747e-06 0.1115 \
7.74702e-06 0.1125 7.751e-06 0.1125 7.75102e-06 0.111 7.755e-06 0.111 7.75502e-06 0.1135 7.759e-06 0.1135 7.75902e-06 0.11275 7.763e-06 0.11275 7.76302e-06 0.1115 7.767e-06 0.1115 7.76702e-06 0.114 7.771e-06 0.114 \
7.77102e-06 0.11225 7.775e-06 0.11225 7.77502e-06 0.112 7.779e-06 0.112 7.77902e-06 0.113 7.783e-06 0.113 7.78302e-06 0.1125 7.787e-06 0.1125 7.78702e-06 0.114 7.791e-06 0.114 7.79102e-06 0.112 7.795e-06 0.112 \
7.79502e-06 0.1115 7.799e-06 0.1115 7.79902e-06 0.11275 7.803e-06 0.11275 7.80302e-06 0.11225 7.807e-06 0.11225 7.80702e-06 0.1125 7.811e-06 0.1125 7.81102e-06 0.113 7.815e-06 0.113 7.81502e-06 0.1135 7.819e-06 0.1135 \
7.81902e-06 0.111 7.823e-06 0.111 7.82302e-06 0.112 7.827e-06 0.112 7.82702e-06 0.11275 7.831e-06 0.11275 7.83102e-06 0.1115 7.835e-06 0.1115 7.83502e-06 0.111 7.839e-06 0.111 7.83902e-06 0.113 7.843e-06 0.113 \
7.84302e-06 0.11225 7.847e-06 0.11225 7.84702e-06 0.114 7.851e-06 0.114 7.85102e-06 0.1125 7.855e-06 0.1125 7.85502e-06 0.1135 7.859e-06 0.1135 7.85902e-06 0.1125 7.863e-06 0.1125 7.86302e-06 0.11225 7.867e-06 0.11225 \
7.86702e-06 0.11275 7.871e-06 0.11275 7.87102e-06 0.113 7.875e-06 0.113 7.87502e-06 0.1115 7.879e-06 0.1115 7.87902e-06 0.114 7.883e-06 0.114 7.88302e-06 0.112 7.887e-06 0.112 7.88702e-06 0.1135 7.891e-06 0.1135 \
7.89102e-06 0.111 7.895e-06 0.111 7.89502e-06 0.11225 7.899e-06 0.11225 7.89902e-06 0.114 7.903e-06 0.114 7.90302e-06 0.1135 7.907e-06 0.1135 7.90702e-06 0.112 7.911e-06 0.112 7.91102e-06 0.111 7.915e-06 0.111 \
7.91502e-06 0.1125 7.919e-06 0.1125 7.91902e-06 0.113 7.923e-06 0.113 7.92302e-06 0.1115 7.927e-06 0.1115 7.92702e-06 0.11275 7.931e-06 0.11275 7.93102e-06 0.111 7.935e-06 0.111 7.93502e-06 0.1125 7.939e-06 0.1125 \
7.93902e-06 0.112 7.943e-06 0.112 7.94302e-06 0.113 7.947e-06 0.113 7.94702e-06 0.114 7.951e-06 0.114 7.95102e-06 0.1115 7.955e-06 0.1115 7.95502e-06 0.1135 7.959e-06 0.1135 7.95902e-06 0.11225 7.963e-06 0.11225 \
7.96302e-06 0.11275 7.967e-06 0.11275 7.96702e-06 0.11275 7.971e-06 0.11275 7.97102e-06 0.1135 7.975e-06 0.1135 7.97502e-06 0.1115 7.979e-06 0.1115 7.97902e-06 0.1125 7.983e-06 0.1125 7.98302e-06 0.114 7.987e-06 0.114 \
7.98702e-06 0.111 7.991e-06 0.111 7.99102e-06 0.11225 7.995e-06 0.11225 7.99502e-06 0.112 7.999e-06 0.112 7.99902e-06 0.113 8.003e-06 0.113 8.00302e-06 0.11275 8.007e-06 0.11275 8.00702e-06 0.112 8.011e-06 0.112 \
8.01102e-06 0.1115 8.015e-06 0.1115 8.01502e-06 0.11225 8.019e-06 0.11225 8.01902e-06 0.114 8.023e-06 0.114 8.02302e-06 0.1135 8.027e-06 0.1135 8.02702e-06 0.113 8.031e-06 0.113 8.03102e-06 0.111 8.035e-06 0.111 \
8.03502e-06 0.1125 8.039e-06 0.1125 8.03902e-06 0.1115 8.043e-06 0.1115 8.04302e-06 0.11275 8.047e-06 0.11275 8.04702e-06 0.113 8.051e-06 0.113 8.05102e-06 0.111 8.055e-06 0.111 8.05502e-06 0.1135 8.059e-06 0.1135 \
8.05902e-06 0.1125 8.063e-06 0.1125 8.06302e-06 0.11225 8.067e-06 0.11225 8.06702e-06 0.112 8.071e-06 0.112 8.07102e-06 0.114 8.075e-06 0.114 8.07502e-06 0.11275 8.079e-06 0.11275 8.07902e-06 0.111 8.083e-06 0.111 \
8.08302e-06 0.114 8.087e-06 0.114 8.08702e-06 0.113 8.091e-06 0.113 8.09102e-06 0.1125 8.095e-06 0.1125 8.09502e-06 0.1135 8.099e-06 0.1135 8.09902e-06 0.1115 8.103e-06 0.1115 8.10302e-06 0.112 8.107e-06 0.112 \
8.10702e-06 0.11225 8.111e-06 0.11225 8.11102e-06 0.11275 8.115e-06 0.11275 8.11502e-06 0.111 8.119e-06 0.111 8.11902e-06 0.112 8.123e-06 0.112 8.12302e-06 0.113 8.127e-06 0.113 8.12702e-06 0.11225 8.131e-06 0.11225 \
8.13102e-06 0.1135 8.135e-06 0.1135 8.13502e-06 0.1125 8.139e-06 0.1125 8.13902e-06 0.1115 8.143e-06 0.1115 8.14302e-06 0.114 8.147e-06 0.114 8.14702e-06 0.1135 8.151e-06 0.1135 8.15102e-06 0.114 8.155e-06 0.114 \
8.15502e-06 0.113 8.159e-06 0.113 8.15902e-06 0.1115 8.163e-06 0.1115 8.16302e-06 0.1125 8.167e-06 0.1125 8.16702e-06 0.111 8.171e-06 0.111 8.17102e-06 0.112 8.175e-06 0.112 8.17502e-06 0.11275 8.179e-06 0.11275 \
8.17902e-06 0.11225 8.183e-06 0.11225 8.18302e-06 0.1135 8.187e-06 0.1135 8.18702e-06 0.1125 8.191e-06 0.1125 8.19102e-06 0.112 8.195e-06 0.112 8.19502e-06 0.113 8.199e-06 0.113 8.19902e-06 0.111 8.203e-06 0.111 \
8.20302e-06 0.114 8.207e-06 0.114 8.20702e-06 0.11275 8.211e-06 0.11275 8.21102e-06 0.1115 8.215e-06 0.1115 8.21502e-06 0.11225 8.219e-06 0.11225 8.21902e-06 0.1135 8.223e-06 0.1135 8.22302e-06 0.111 8.227e-06 0.111 \
8.22702e-06 0.113 8.231e-06 0.113 8.23102e-06 0.11225 8.235e-06 0.11225 8.23502e-06 0.1115 8.239e-06 0.1115 8.23902e-06 0.1125 8.243e-06 0.1125 8.24302e-06 0.114 8.247e-06 0.114 8.24702e-06 0.11275 8.251e-06 0.11275 \
8.25102e-06 0.112 8.255e-06 0.112 8.25502e-06 0.11225 8.259e-06 0.11225 8.25902e-06 0.111 8.263e-06 0.111 8.26302e-06 0.113 8.267e-06 0.113 8.26702e-06 0.11275 8.271e-06 0.11275 8.27102e-06 0.1125 8.275e-06 0.1125 \
8.27502e-06 0.1135 8.279e-06 0.1135 8.27902e-06 0.1115 8.283e-06 0.1115 8.28302e-06 0.114 8.287e-06 0.114 8.28702e-06 0.112 8.291e-06 0.112 8.29102e-06 0.11225 8.295e-06 0.11225 8.29502e-06 0.1115 8.299e-06 0.1115 \
8.29902e-06 0.112 8.303e-06 0.112 8.30302e-06 0.1125 8.307e-06 0.1125 8.30702e-06 0.111 8.311e-06 0.111 8.31102e-06 0.11275 8.315e-06 0.11275 8.31502e-06 0.114 8.319e-06 0.114 8.31902e-06 0.113 8.323e-06 0.113 \
8.32302e-06 0.1135 8.327e-06 0.1135 8.32702e-06 0.1125 8.331e-06 0.1125 8.33102e-06 0.112 8.335e-06 0.112 8.33502e-06 0.113 8.339e-06 0.113 8.33902e-06 0.1115 8.343e-06 0.1115 8.34302e-06 0.111 8.347e-06 0.111 \
8.34702e-06 0.11225 8.351e-06 0.11225 8.35102e-06 0.1135 8.355e-06 0.1135 8.35502e-06 0.114 8.359e-06 0.114 8.35902e-06 0.11275 8.363e-06 0.11275 8.36302e-06 0.114 8.367e-06 0.114 8.36702e-06 0.1115 8.371e-06 0.1115 \
8.37102e-06 0.112 8.375e-06 0.112 8.37502e-06 0.1135 8.379e-06 0.1135 8.37902e-06 0.113 8.383e-06 0.113 8.38302e-06 0.11225 8.387e-06 0.11225 8.38702e-06 0.111 8.391e-06 0.111 8.39102e-06 0.11275 8.395e-06 0.11275 \
8.39502e-06 0.1125 8.399e-06 0.1125 8.39902e-06 0.11225 8.403e-06 0.11225 8.40302e-06 0.1115 8.407e-06 0.1115 8.40702e-06 0.113 8.411e-06 0.113 8.41102e-06 0.1135 8.415e-06 0.1135 8.41502e-06 0.112 8.419e-06 0.112 \
8.41902e-06 0.111 8.423e-06 0.111 8.42302e-06 0.11275 8.427e-06 0.11275 8.42702e-06 0.1125 8.431e-06 0.1125 8.43102e-06 0.114 8.435e-06 0.114 8.43502e-06 0.1135 8.439e-06 0.1135 8.43902e-06 0.1115 8.443e-06 0.1115 \
8.44302e-06 0.1125 8.447e-06 0.1125 8.44702e-06 0.111 8.451e-06 0.111 8.45102e-06 0.113 8.455e-06 0.113 8.45502e-06 0.11225 8.459e-06 0.11225 8.45902e-06 0.114 8.463e-06 0.114 8.46302e-06 0.112 8.467e-06 0.112 \
8.46702e-06 0.11275 8.471e-06 0.11275 8.47102e-06 0.11275 8.475e-06 0.11275 8.47502e-06 0.11225 8.479e-06 0.11225 8.47902e-06 0.1135 8.483e-06 0.1135 8.48302e-06 0.112 8.487e-06 0.112 8.48702e-06 0.1125 8.491e-06 0.1125 \
8.49102e-06 0.114 8.495e-06 0.114 8.49502e-06 0.111 8.499e-06 0.111 8.49902e-06 0.1115 8.503e-06 0.1115 8.50302e-06 0.113 8.507e-06 0.113 8.50702e-06 0.1135 8.511e-06 0.1135 8.51102e-06 0.112 8.515e-06 0.112 \
8.51502e-06 0.111 8.519e-06 0.111 8.51902e-06 0.113 8.523e-06 0.113 8.52302e-06 0.11275 8.527e-06 0.11275 8.52702e-06 0.114 8.531e-06 0.114 8.53102e-06 0.1115 8.535e-06 0.1115 8.53502e-06 0.11225 8.539e-06 0.11225 \
8.53902e-06 0.1125 8.543e-06 0.1125 8.54302e-06 0.11275 8.547e-06 0.11275 8.54702e-06 0.1115 8.551e-06 0.1115 8.55102e-06 0.112 8.555e-06 0.112 8.55502e-06 0.113 8.559e-06 0.113 8.55902e-06 0.11225 8.563e-06 0.11225 \
8.56302e-06 0.1125 8.567e-06 0.1125 8.56702e-06 0.1135 8.571e-06 0.1135 8.57102e-06 0.114 8.575e-06 0.114 8.57502e-06 0.111 8.579e-06 0.111 8.57902e-06 0.112 8.583e-06 0.112 8.58302e-06 0.113 8.587e-06 0.113 \
8.58702e-06 0.1125 8.591e-06 0.1125 8.59102e-06 0.1115 8.595e-06 0.1115 8.59502e-06 0.1135 8.599e-06 0.1135 8.59902e-06 0.11275 8.603e-06 0.11275 8.60302e-06 0.114 8.607e-06 0.114 8.60702e-06 0.111 8.611e-06 0.111 \
8.61102e-06 0.11225 8.615e-06 0.11225 8.61502e-06 0.114 8.619e-06 0.114 8.61902e-06 0.11275 8.623e-06 0.11275 8.62302e-06 0.1125 8.627e-06 0.1125 8.62702e-06 0.111 8.631e-06 0.111 8.63102e-06 0.1115 8.635e-06 0.1115 \
8.63502e-06 0.1135 8.639e-06 0.1135 8.63902e-06 0.113 8.643e-06 0.113 8.64302e-06 0.11225 8.647e-06 0.11225 8.64702e-06 0.112 8.651e-06 0.112 8.65102e-06 0.114 8.655e-06 0.114 8.65502e-06 0.112 8.659e-06 0.112 \
8.65902e-06 0.11225 8.663e-06 0.11225 8.66302e-06 0.113 8.667e-06 0.113 8.66702e-06 0.1135 8.671e-06 0.1135 8.67102e-06 0.11275 8.675e-06 0.11275 8.67502e-06 0.111 8.679e-06 0.111 8.67902e-06 0.1115 8.683e-06 0.1115 \
8.68302e-06 0.1125 8.687e-06 0.1125 8.68702e-06 0.11225 8.691e-06 0.11225 8.69102e-06 0.112 8.695e-06 0.112 8.69502e-06 0.1125 8.699e-06 0.1125 8.69902e-06 0.113 8.703e-06 0.113 8.70302e-06 0.1135 8.707e-06 0.1135 \
8.70702e-06 0.114 8.711e-06 0.114 8.71102e-06 0.111 8.715e-06 0.111 8.71502e-06 0.11275 8.719e-06 0.11275 8.71902e-06 0.1115 8.723e-06 0.1115 8.72302e-06 0.112 8.727e-06 0.112 8.72702e-06 0.11225 8.731e-06 0.11225 \
8.73102e-06 0.1125 8.735e-06 0.1125 8.73502e-06 0.114 8.739e-06 0.114 8.73902e-06 0.11275 8.743e-06 0.11275 8.74302e-06 0.1135 8.747e-06 0.1135 8.74702e-06 0.111 8.751e-06 0.111 8.75102e-06 0.113 8.755e-06 0.113 \
8.75502e-06 0.1115 8.759e-06 0.1115 8.75902e-06 0.1135 8.763e-06 0.1135 8.76302e-06 0.112 8.767e-06 0.112 8.76702e-06 0.1125 8.771e-06 0.1125 8.77102e-06 0.1115 8.775e-06 0.1115 8.77502e-06 0.111 8.779e-06 0.111 \
8.77902e-06 0.113 8.783e-06 0.113 8.78302e-06 0.11275 8.787e-06 0.11275 8.78702e-06 0.11225 8.791e-06 0.11225 8.79102e-06 0.114 8.795e-06 0.114 8.79502e-06 0.112 8.799e-06 0.112 8.79902e-06 0.113 8.803e-06 0.113 \
8.80302e-06 0.1115 8.807e-06 0.1115 8.80702e-06 0.11275 8.811e-06 0.11275 8.81102e-06 0.1125 8.815e-06 0.1125 8.81502e-06 0.111 8.819e-06 0.111 8.81902e-06 0.1135 8.823e-06 0.1135 8.82302e-06 0.114 8.827e-06 0.114 \
8.82702e-06 0.11225 8.831e-06 0.11225 8.83102e-06 0.11275 8.835e-06 0.11275 8.83502e-06 0.1115 8.839e-06 0.1115 8.83902e-06 0.1125 8.843e-06 0.1125 8.84302e-06 0.111 8.847e-06 0.111 8.84702e-06 0.113 8.851e-06 0.113 \
8.85102e-06 0.112 8.855e-06 0.112 8.85502e-06 0.114 8.859e-06 0.114 8.85902e-06 0.1135 8.863e-06 0.1135 8.86302e-06 0.11225 8.867e-06 0.11225 8.86702e-06 0.11225 8.871e-06 0.11225 8.87102e-06 0.114 8.875e-06 0.114 \
8.87502e-06 0.113 8.879e-06 0.113 8.87902e-06 0.1125 8.883e-06 0.1125 8.88302e-06 0.11275 8.887e-06 0.11275 8.88702e-06 0.1115 8.891e-06 0.1115 8.89102e-06 0.111 8.895e-06 0.111 8.89502e-06 0.1135 8.899e-06 0.1135 \
8.89902e-06 0.112 8.903e-06 0.112 8.90302e-06 0.112 8.907e-06 0.112 8.90702e-06 0.11275 8.911e-06 0.11275 8.91102e-06 0.111 8.915e-06 0.111 8.91502e-06 0.113 8.919e-06 0.113 8.91902e-06 0.1125 8.923e-06 0.1125 \
8.92302e-06 0.114 8.927e-06 0.114 8.92702e-06 0.1135 8.931e-06 0.1135 8.93102e-06 0.1115 8.935e-06 0.1115 8.93502e-06 0.11225 8.939e-06 0.11225 8.93902e-06 0.11275 8.943e-06 0.11275 8.94302e-06 0.1115 8.947e-06 0.1115 \
8.94702e-06 0.114 8.951e-06 0.114 8.95102e-06 0.111 8.955e-06 0.111 8.95502e-06 0.112 8.959e-06 0.112 8.95902e-06 0.1135 8.963e-06 0.1135 8.96302e-06 0.11225 8.967e-06 0.11225 8.96702e-06 0.113 8.971e-06 0.113 \
8.97102e-06 0.1125 8.975e-06 0.1125 8.97502e-06 0.111 8.979e-06 0.111 8.97902e-06 0.11275 8.983e-06 0.11275 8.98302e-06 0.112 8.987e-06 0.112 8.98702e-06 0.113 8.991e-06 0.113 8.99102e-06 0.1115 8.995e-06 0.1115 \
8.99502e-06 0.1135 8.999e-06 0.1135 8.99902e-06 0.1125 9.003e-06 0.1125 9.00302e-06 0.114 9.007e-06 0.114 9.00702e-06 0.11225 9.011e-06 0.11225 9.01102e-06 0.112 9.015e-06 0.112 9.01502e-06 0.114 9.019e-06 0.114 \
9.01902e-06 0.111 9.023e-06 0.111 9.02302e-06 0.113 9.027e-06 0.113 9.02702e-06 0.1115 9.031e-06 0.1115 9.03102e-06 0.1125 9.035e-06 0.1125 9.03502e-06 0.11275 9.039e-06 0.11275 9.03902e-06 0.11225 9.043e-06 0.11225 \
9.04302e-06 0.1135 9.047e-06 0.1135 9.04702e-06 0.114 9.051e-06 0.114 9.05102e-06 0.1115 9.055e-06 0.1115 9.05502e-06 0.11225 9.059e-06 0.11225 9.05902e-06 0.11275 9.063e-06 0.11275 9.06302e-06 0.1125 9.067e-06 0.1125 \
9.06702e-06 0.113 9.071e-06 0.113 9.07102e-06 0.1135 9.075e-06 0.1135 9.07502e-06 0.112 9.079e-06 0.112 9.07902e-06 0.111 9.083e-06 0.111 9.08302e-06 0.112 9.087e-06 0.112 9.08702e-06 0.114 9.091e-06 0.114 \
9.09102e-06 0.1115 9.095e-06 0.1115 9.09502e-06 0.11275 9.099e-06 0.11275 9.09902e-06 0.1125 9.103e-06 0.1125 9.10302e-06 0.113 9.107e-06 0.113 9.10702e-06 0.1135 9.111e-06 0.1135 9.11102e-06 0.111 9.115e-06 0.111 \
9.11502e-06 0.11225 9.119e-06 0.11225 9.11902e-06 0.113 9.123e-06 0.113 9.12302e-06 0.11275 9.127e-06 0.11275 9.12702e-06 0.1115 9.131e-06 0.1115 9.13102e-06 0.112 9.135e-06 0.112 9.13502e-06 0.114 9.139e-06 0.114 \
9.13902e-06 0.1135 9.143e-06 0.1135 9.14302e-06 0.11225 9.147e-06 0.11225 9.14702e-06 0.1125 9.151e-06 0.1125 9.15102e-06 0.111 9.155e-06 0.111 9.15502e-06 0.114 9.159e-06 0.114 9.15902e-06 0.11275 9.163e-06 0.11275 \
9.16302e-06 0.11225 9.167e-06 0.11225 9.16702e-06 0.1115 9.171e-06 0.1115 9.17102e-06 0.111 9.175e-06 0.111 9.17502e-06 0.1125 9.179e-06 0.1125 9.17902e-06 0.112 9.183e-06 0.112 9.18302e-06 0.1135 9.187e-06 0.1135 \
9.18702e-06 0.113 9.191e-06 0.113 9.19102e-06 0.111 9.195e-06 0.111 9.19502e-06 0.11225 9.199e-06 0.11225 9.19902e-06 0.114 9.203e-06 0.114 9.20302e-06 0.1115 9.207e-06 0.1115 9.20702e-06 0.1135 9.211e-06 0.1135 \
9.21102e-06 0.1125 9.215e-06 0.1125 9.21502e-06 0.112 9.219e-06 0.112 9.21902e-06 0.11275 9.223e-06 0.11275 9.22302e-06 0.113 9.227e-06 0.113 9.22702e-06 0.11225 9.231e-06 0.11225 9.23102e-06 0.112 9.235e-06 0.112 \
9.23502e-06 0.111 9.239e-06 0.111 9.23902e-06 0.113 9.243e-06 0.113 9.24302e-06 0.114 9.247e-06 0.114 9.24702e-06 0.1125 9.251e-06 0.1125 9.25102e-06 0.1135 9.255e-06 0.1135 9.25502e-06 0.11275 9.259e-06 0.11275 \
9.25902e-06 0.1115 9.263e-06 0.1115 9.26302e-06 0.1115 9.267e-06 0.1115 9.26702e-06 0.11275 9.271e-06 0.11275 9.27102e-06 0.1135 9.275e-06 0.1135 9.27502e-06 0.111 9.279e-06 0.111 9.27902e-06 0.11225 9.283e-06 0.11225 \
9.28302e-06 0.113 9.287e-06 0.113 9.28702e-06 0.112 9.291e-06 0.112 9.29102e-06 0.1125 9.295e-06 0.1125 9.29502e-06 0.114 9.299e-06 0.114 9.29902e-06 0.114 9.303e-06 0.114 9.30302e-06 0.1125 9.307e-06 0.1125 \
9.30702e-06 0.1115 9.311e-06 0.1115 9.31102e-06 0.11275 9.315e-06 0.11275 9.31502e-06 0.1135 9.319e-06 0.1135 9.31902e-06 0.11225 9.323e-06 0.11225 9.32302e-06 0.113 9.327e-06 0.113 9.32702e-06 0.112 9.331e-06 0.112 \
9.33102e-06 0.111 9.335e-06 0.111 9.33502e-06 0.0020078125 9.339e-06 0.0020078125 9.33902e-06 0.0032578125 9.343e-06 0.0032578125 9.34302e-06 0.0007578125 9.347e-06 0.0007578125 9.34702e-06 0.0012578125 9.351e-06 0.0012578125 9.35102e-06 0.0022578125 9.355e-06 0.0022578125 \
9.35502e-06 0.0017578125 9.359e-06 0.0017578125 9.35902e-06 0.0015078125 9.363e-06 0.0015078125 9.36302e-06 0.0027578125 9.367e-06 0.0027578125 9.36702e-06 0.0002578125 9.371e-06 0.0002578125 9.37102e-06 0.0017578125 9.375e-06 0.0017578125 9.37502e-06 0.0007578125 9.379e-06 0.0007578125 \
9.37902e-06 0.0012578125 9.383e-06 0.0012578125 9.38302e-06 0.0002578125 9.387e-06 0.0002578125 9.38702e-06 0.0022578125 9.391e-06 0.0022578125 9.39102e-06 0.0020078125 9.395e-06 0.0020078125 9.39502e-06 0.0015078125 9.399e-06 0.0015078125 9.39902e-06 0.0027578125 9.403e-06 0.0027578125 \
9.40302e-06 0.0032578125 9.407e-06 0.0032578125 9.40702e-06 0.0015078125 9.411e-06 0.0015078125 9.41102e-06 0.0017578125 9.415e-06 0.0017578125 9.41502e-06 0.0012578125 9.419e-06 0.0012578125 9.41902e-06 0.0022578125 9.423e-06 0.0022578125 9.42302e-06 0.0020078125 9.427e-06 0.0020078125 \
9.42702e-06 0.0027578125 9.431e-06 0.0027578125 9.43102e-06 0.0007578125 9.435e-06 0.0007578125 9.43502e-06 0.0032578125 9.439e-06 0.0032578125 9.43902e-06 0.0002578125 9.443e-06 0.0002578125 9.44302e-06 0.0032578125 9.447e-06 0.0032578125 9.44702e-06 0.0022578125 9.451e-06 0.0022578125 \
9.45102e-06 0.0027578125 9.455e-06 0.0027578125 9.45502e-06 0.0020078125 9.459e-06 0.0020078125 9.45902e-06 0.0015078125 9.463e-06 0.0015078125 9.46302e-06 0.0017578125 9.467e-06 0.0017578125 9.46702e-06 0.0007578125 9.471e-06 0.0007578125 9.47102e-06 0.0012578125 9.475e-06 0.0012578125 \
9.47502e-06 0.0002578125 9.479e-06 0.0002578125 9.47902e-06 0.0002578125 9.483e-06 0.0002578125 9.48302e-06 0.0027578125 9.487e-06 0.0027578125 9.48702e-06 0.0017578125 9.491e-06 0.0017578125 9.49102e-06 0.0020078125 9.495e-06 0.0020078125 9.49502e-06 0.0032578125 9.499e-06 0.0032578125 \
9.49902e-06 0.0007578125 9.503e-06 0.0007578125 9.50302e-06 0.0022578125 9.507e-06 0.0022578125 9.50702e-06 0.0012578125 9.511e-06 0.0012578125 9.51102e-06 0.0015078125 9.515e-06 0.0015078125 9.51502e-06 0.0012578125 9.519e-06 0.0012578125 9.51902e-06 0.0017578125 9.523e-06 0.0017578125 \
9.52302e-06 0.0032578125 9.527e-06 0.0032578125 9.52702e-06 0.0022578125 9.531e-06 0.0022578125 9.53102e-06 0.0027578125 9.535e-06 0.0027578125 9.53502e-06 0.0002578125 9.539e-06 0.0002578125 9.53902e-06 0.0020078125 9.543e-06 0.0020078125 9.54302e-06 0.0007578125 9.547e-06 0.0007578125 \
9.54702e-06 0.0015078125 9.551e-06 0.0015078125 9.55102e-06 0.0007578125 9.555e-06 0.0007578125 9.55502e-06 0.0002578125 9.559e-06 0.0002578125 9.55902e-06 0.0020078125 9.563e-06 0.0020078125 9.56302e-06 0.0015078125 9.567e-06 0.0015078125 9.56702e-06 0.0027578125 9.571e-06 0.0027578125 \
9.57102e-06 0.0022578125 9.575e-06 0.0022578125 9.57502e-06 0.0012578125 9.579e-06 0.0012578125 9.57902e-06 0.0032578125 9.583e-06 0.0032578125 9.58302e-06 0.0017578125 9.587e-06 0.0017578125 9.58702e-06 0.0027578125 9.591e-06 0.0027578125 9.59102e-06 0.0007578125 9.595e-06 0.0007578125 \
9.59502e-06 0.0015078125 9.599e-06 0.0015078125 9.59902e-06 0.0020078125 9.603e-06 0.0020078125 9.60302e-06 0.0017578125 9.607e-06 0.0017578125 9.60702e-06 0.0002578125 9.611e-06 0.0002578125 9.61102e-06 0.0022578125 9.615e-06 0.0022578125 9.61502e-06 0.0032578125 9.619e-06 0.0032578125 \
9.61902e-06 0.0012578125 9.623e-06 0.0012578125 9.62302e-06 0.0020078125 9.627e-06 0.0020078125 9.62702e-06 0.0017578125 9.631e-06 0.0017578125 9.63102e-06 0.0015078125 9.635e-06 0.0015078125 9.63502e-06 0.0012578125 9.639e-06 0.0012578125 9.63902e-06 0.0007578125 9.643e-06 0.0007578125 \
9.64302e-06 0.0022578125 9.647e-06 0.0022578125 9.64702e-06 0.0032578125 9.651e-06 0.0032578125 9.65102e-06 0.0027578125 9.655e-06 0.0027578125 9.65502e-06 0.0002578125 9.659e-06 0.0002578125 9.65902e-06 0.0002578125 9.663e-06 0.0002578125 9.66302e-06 0.0015078125 9.667e-06 0.0015078125 \
9.66702e-06 0.0017578125 9.671e-06 0.0017578125 9.67102e-06 0.0032578125 9.675e-06 0.0032578125 9.67502e-06 0.0012578125 9.679e-06 0.0012578125 9.67902e-06 0.0027578125 9.683e-06 0.0027578125 9.68302e-06 0.0022578125 9.687e-06 0.0022578125 9.68702e-06 0.0007578125 9.691e-06 0.0007578125 \
9.69102e-06 0.0020078125 9.695e-06 0.0020078125 9.69502e-06 0.0020078125 9.699e-06 0.0020078125 9.69902e-06 0.0002578125 9.703e-06 0.0002578125 9.70302e-06 0.0032578125 9.707e-06 0.0032578125 9.70702e-06 0.0015078125 9.711e-06 0.0015078125 9.71102e-06 0.0017578125 9.715e-06 0.0017578125 \
9.71502e-06 0.0012578125 9.719e-06 0.0012578125 9.71902e-06 0.0022578125 9.723e-06 0.0022578125 9.72302e-06 0.0027578125 9.727e-06 0.0027578125 9.72702e-06 0.0007578125 9.731e-06 0.0007578125 9.73102e-06 0.0032578125 9.735e-06 0.0032578125 9.73502e-06 0.0002578125 9.739e-06 0.0002578125 \
9.73902e-06 0.0017578125 9.743e-06 0.0017578125 9.74302e-06 0.0015078125 9.747e-06 0.0015078125 9.74702e-06 0.0027578125 9.751e-06 0.0027578125 9.75102e-06 0.0022578125 9.755e-06 0.0022578125 9.75502e-06 0.0012578125 9.759e-06 0.0012578125 9.75902e-06 0.0007578125 9.763e-06 0.0007578125 \
9.76302e-06 0.0020078125 9.767e-06 0.0020078125 9.76702e-06 0.0015078125 9.771e-06 0.0015078125 9.77102e-06 0.0027578125 9.775e-06 0.0027578125 9.77502e-06 0.0012578125 9.779e-06 0.0012578125 9.77902e-06 0.0002578125 9.783e-06 0.0002578125 9.78302e-06 0.0022578125 9.787e-06 0.0022578125 \
9.78702e-06 0.0017578125 9.791e-06 0.0017578125 9.79102e-06 0.0007578125 9.795e-06 0.0007578125 9.79502e-06 0.0032578125 9.799e-06 0.0032578125 9.79902e-06 0.0020078125 9.803e-06 0.0020078125 9.80302e-06 0.0027578125 9.807e-06 0.0027578125 9.80702e-06 0.0020078125 9.811e-06 0.0020078125 \
9.81102e-06 0.0007578125 9.815e-06 0.0007578125 9.81502e-06 0.0017578125 9.819e-06 0.0017578125 9.81902e-06 0.0012578125 9.823e-06 0.0012578125 9.82302e-06 0.0022578125 9.827e-06 0.0022578125 9.82702e-06 0.0015078125 9.831e-06 0.0015078125 9.83102e-06 0.0032578125 9.835e-06 0.0032578125 \
9.83502e-06 0.0002578125 9.839e-06 0.0002578125 9.83902e-06 0.0012578125 9.843e-06 0.0012578125 9.84302e-06 0.0020078125 9.847e-06 0.0020078125 9.84702e-06 0.0017578125 9.851e-06 0.0017578125 9.85102e-06 0.0022578125 9.855e-06 0.0022578125 9.85502e-06 0.0002578125 9.859e-06 0.0002578125 \
9.85902e-06 0.0015078125 9.863e-06 0.0015078125 9.86302e-06 0.0032578125 9.867e-06 0.0032578125 9.86702e-06 0.0027578125 9.871e-06 0.0027578125 9.87102e-06 0.0007578125 9.875e-06 0.0007578125 9.87502e-06 0.0027578125 9.879e-06 0.0027578125 9.87902e-06 0.0022578125 9.883e-06 0.0022578125 \
9.88302e-06 0.0002578125 9.887e-06 0.0002578125 9.88702e-06 0.0017578125 9.891e-06 0.0017578125 9.89102e-06 0.0012578125 9.895e-06 0.0012578125 9.89502e-06 0.0007578125 9.899e-06 0.0007578125 9.89902e-06 0.0032578125 9.903e-06 0.0032578125 9.90302e-06 0.0015078125 9.907e-06 0.0015078125 \
9.90702e-06 0.0020078125 9.911e-06 0.0020078125 9.91102e-06 0.0020078125 9.915e-06 0.0020078125 9.91502e-06 0.0027578125 9.919e-06 0.0027578125 9.91902e-06 0.0002578125 9.923e-06 0.0002578125 9.92302e-06 0.0032578125 9.927e-06 0.0032578125 9.92702e-06 0.0012578125 9.931e-06 0.0012578125 \
9.93102e-06 0.0015078125 9.935e-06 0.0015078125 9.93502e-06 0.0022578125 9.939e-06 0.0022578125 9.93902e-06 0.0007578125 9.943e-06 0.0007578125 9.94302e-06 0.0017578125 9.947e-06 0.0017578125 9.94702e-06 0.0012578125 9.951e-06 0.0012578125 9.95102e-06 0.0020078125 9.955e-06 0.0020078125 \
9.95502e-06 0.0027578125 9.959e-06 0.0027578125 9.95902e-06 0.0015078125 9.963e-06 0.0015078125 9.96302e-06 0.0002578125 9.967e-06 0.0002578125 9.96702e-06 0.0007578125 9.971e-06 0.0007578125 9.97102e-06 0.0017578125 9.975e-06 0.0017578125 9.97502e-06 0.0022578125 9.979e-06 0.0022578125 \
9.97902e-06 0.0032578125 9.983e-06 0.0032578125 9.98302e-06 0.0027578125 9.987e-06 0.0027578125 9.98702e-06 0.0017578125 9.991e-06 0.0017578125 9.99102e-06 0.0020078125 9.995e-06 0.0020078125 9.99502e-06 0.0002578125 9.999e-06 0.0002578125 9.99902e-06 0.0012578125 1.0003e-05 0.0012578125 \
1.000302e-05 0.0015078125 1.0007e-05 0.0015078125 1.000702e-05 0.0032578125 1.0011e-05 0.0032578125 1.001102e-05 0.0022578125 1.0015e-05 0.0022578125 1.001502e-05 0.0007578125 1.0019e-05 0.0007578125 1.001902e-05 0.0012578125 1.0023e-05 0.0012578125 1.002302e-05 0.0015078125 1.0027e-05 0.0015078125 \
1.002702e-05 0.0032578125 1.0031e-05 0.0032578125 1.003102e-05 0.0027578125 1.0035e-05 0.0027578125 1.003502e-05 0.0022578125 1.0039e-05 0.0022578125 1.003902e-05 0.0017578125 1.0043e-05 0.0017578125 1.004302e-05 0.0002578125 1.0047e-05 0.0002578125 1.004702e-05 0.0007578125 1.0051e-05 0.0007578125 \
1.005102e-05 0.0020078125 1.0055e-05 0.0020078125 1.005502e-05 0.0027578125 1.0059e-05 0.0027578125 1.005902e-05 0.0007578125 1.0063e-05 0.0007578125 1.006302e-05 0.0015078125 1.0067e-05 0.0015078125 1.006702e-05 0.0020078125 1.0071e-05 0.0020078125 1.007102e-05 0.0002578125 1.0075e-05 0.0002578125 \
1.007502e-05 0.0012578125 1.0079e-05 0.0012578125 1.007902e-05 0.0022578125 1.0083e-05 0.0022578125 1.008302e-05 0.0017578125 1.0087e-05 0.0017578125 1.008702e-05 0.0032578125 1.0091e-05 0.0032578125 1.009102e-05 0.0002578125 1.0095e-05 0.0002578125 1.009502e-05 0.0022578125 1.0099e-05 0.0022578125 \
1.009902e-05 0.0032578125 1.0103e-05 0.0032578125 1.010302e-05 0.0012578125 1.0107e-05 0.0012578125 1.010702e-05 0.0017578125 1.0111e-05 0.0017578125 1.011102e-05 0.0020078125 1.0115e-05 0.0020078125 1.011502e-05 0.0027578125 1.0119e-05 0.0027578125 1.011902e-05 0.0015078125 1.0123e-05 0.0015078125 \
1.012302e-05 0.0007578125 1.0127e-05 0.0007578125 1.012702e-05 0.0012578125 1.0131e-05 0.0012578125 1.013102e-05 0.0020078125 1.0135e-05 0.0020078125 1.013502e-05 0.0007578125 1.0139e-05 0.0007578125 1.013902e-05 0.0027578125 1.0143e-05 0.0027578125 1.014302e-05 0.0022578125 1.0147e-05 0.0022578125 \
1.014702e-05 0.0017578125 1.0151e-05 0.0017578125 1.015102e-05 0.0032578125 1.0155e-05 0.0032578125 1.015502e-05 0.0015078125 1.0159e-05 0.0015078125 1.015902e-05 0.0002578125 1.0163e-05 0.0002578125 1.016302e-05 0.0012578125 1.0167e-05 0.0012578125 1.016702e-05 0.0020078125 1.0171e-05 0.0020078125 \
1.017102e-05 0.0022578125 1.0175e-05 0.0022578125 1.017502e-05 0.0007578125 1.0179e-05 0.0007578125 1.017902e-05 0.0002578125 1.0183e-05 0.0002578125 1.018302e-05 0.0015078125 1.0187e-05 0.0015078125 1.018702e-05 0.0027578125 1.0191e-05 0.0027578125 1.019102e-05 0.0032578125 1.0195e-05 0.0032578125 \
1.019502e-05 0.0017578125 1.0199e-05 0.0017578125 1.019902e-05 0.0002578125 1.0203e-05 0.0002578125 1.020302e-05 0.0032578125 1.0207e-05 0.0032578125 1.020702e-05 0.0015078125 1.0211e-05 0.0015078125 1.021102e-05 0.0017578125 1.0215e-05 0.0017578125 1.021502e-05 0.0022578125 1.0219e-05 0.0022578125 \
1.021902e-05 0.0027578125 1.0223e-05 0.0027578125 1.022302e-05 0.0007578125 1.0227e-05 0.0007578125 1.022702e-05 0.0012578125 1.0231e-05 0.0012578125 1.023102e-05 0.0020078125 1.0235e-05 0.0020078125 1.023502e-05 0.0002578125 1.0239e-05 0.0002578125 1.023902e-05 0.0012578125 1.0243e-05 0.0012578125 \
1.024302e-05 0.0032578125 1.0247e-05 0.0032578125 1.024702e-05 0.0022578125 1.0251e-05 0.0022578125 1.025102e-05 0.0017578125 1.0255e-05 0.0017578125 1.025502e-05 0.0020078125 1.0259e-05 0.0020078125 1.025902e-05 0.0027578125 1.0263e-05 0.0027578125 1.026302e-05 0.0015078125 1.0267e-05 0.0015078125 \
1.026702e-05 0.0007578125 1.0271e-05 0.0007578125 1.027102e-05 0.0022578125 1.0275e-05 0.0022578125 1.027502e-05 0.0002578125 1.0279e-05 0.0002578125 1.027902e-05 0.0020078125 1.0283e-05 0.0020078125 1.028302e-05 0.0012578125 1.0287e-05 0.0012578125 1.028702e-05 0.0015078125 1.0291e-05 0.0015078125 \
1.029102e-05 0.0032578125 1.0295e-05 0.0032578125 1.029502e-05 0.0007578125 1.0299e-05 0.0007578125 1.029902e-05 0.0027578125 1.0303e-05 0.0027578125 1.030302e-05 0.0017578125 1.0307e-05 0.0017578125 1.030702e-05 0.0002578125 1.0311e-05 0.0002578125 1.031102e-05 0.0015078125 1.0315e-05 0.0015078125 \
1.031502e-05 0.0007578125 1.0319e-05 0.0007578125 1.031902e-05 0.0017578125 1.0323e-05 0.0017578125 1.032302e-05 0.0032578125 1.0327e-05 0.0032578125 1.032702e-05 0.0012578125 1.0331e-05 0.0012578125 1.033102e-05 0.0020078125 1.0335e-05 0.0020078125 1.033502e-05 0.0027578125 1.0339e-05 0.0027578125 \
1.033902e-05 0.0022578125 1.0343e-05 0.0022578125 1.034302e-05 0.0032578125 1.0347e-05 0.0032578125 1.034702e-05 0.0002578125 1.0351e-05 0.0002578125 1.035102e-05 0.0017578125 1.0355e-05 0.0017578125 1.035502e-05 0.0007578125 1.0359e-05 0.0007578125 1.035902e-05 0.0012578125 1.0363e-05 0.0012578125 \
1.036302e-05 0.0020078125 1.0367e-05 0.0020078125 1.036702e-05 0.0027578125 1.0371e-05 0.0027578125 1.037102e-05 0.0022578125 1.0375e-05 0.0022578125 1.037502e-05 0.0015078125 1.0379e-05 0.0015078125 1.037902e-05 0.0027578125 1.0383e-05 0.0027578125 1.038302e-05 0.0012578125 1.0387e-05 0.0012578125 \
1.038702e-05 0.0032578125 1.0391e-05 0.0032578125 1.039102e-05 0.0020078125 1.0395e-05 0.0020078125 1.039502e-05 0.0022578125 1.0399e-05 0.0022578125 1.039902e-05 0.0017578125 1.0403e-05 0.0017578125 1.040302e-05 0.0002578125 1.0407e-05 0.0002578125 1.040702e-05 0.0007578125 1.0411e-05 0.0007578125 \
1.041102e-05 0.0015078125 1.0415e-05 0.0015078125 1.041502e-05 0.0015078125 1.0419e-05 0.0015078125 1.041902e-05 0.0022578125 1.0423e-05 0.0022578125 1.042302e-05 0.0020078125 1.0427e-05 0.0020078125 1.042702e-05 0.0032578125 1.0431e-05 0.0032578125 1.043102e-05 0.0012578125 1.0435e-05 0.0012578125 \
1.043502e-05 0.0017578125 1.0439e-05 0.0017578125 1.043902e-05 0.0002578125 1.0443e-05 0.0002578125 1.044302e-05 0.0007578125 1.0447e-05 0.0007578125 1.044702e-05 0.0027578125 1.0451e-05 0.0027578125 1.045102e-05 0.0015078125 1.0455e-05 0.0015078125 1.045502e-05 0.0027578125 1.0459e-05 0.0027578125 \
1.045902e-05 0.0017578125 1.0463e-05 0.0017578125 1.046302e-05 0.0020078125 1.0467e-05 0.0020078125 1.046702e-05 0.0007578125 1.0471e-05 0.0007578125 1.047102e-05 0.0022578125 1.0475e-05 0.0022578125 1.047502e-05 0.0032578125 1.0479e-05 0.0032578125 1.047902e-05 0.0012578125 1.0483e-05 0.0012578125 \
1.048302e-05 0.0002578125 1.0487e-05 0.0002578125 1.048702e-05 0.0015078125 1.0491e-05 0.0015078125 1.049102e-05 0.0032578125 1.0495e-05 0.0032578125 1.049502e-05 0.0012578125 1.0499e-05 0.0012578125 1.049902e-05 0.0020078125 1.0503e-05 0.0020078125 1.050302e-05 0.0027578125 1.0507e-05 0.0027578125 \
1.050702e-05 0.0022578125 1.0511e-05 0.0022578125 1.051102e-05 0.0002578125 1.0515e-05 0.0002578125 1.051502e-05 0.0017578125 1.0519e-05 0.0017578125 1.051902e-05 0.0007578125 1.0523e-05 0.0007578125 1.052302e-05 0.0012578125 1.0527e-05 0.0012578125 1.052702e-05 0.0007578125 1.0531e-05 0.0007578125 \
1.053102e-05 0.0020078125 1.0535e-05 0.0020078125 1.053502e-05 0.0015078125 1.0539e-05 0.0015078125 1.053902e-05 0.0032578125 1.0543e-05 0.0032578125 1.054302e-05 0.0027578125 1.0547e-05 0.0027578125 1.054702e-05 0.0017578125 1.0551e-05 0.0017578125 1.055102e-05 0.0002578125 1.0555e-05 0.0002578125 \
1.055502e-05 0.0022578125 1.0559e-05 0.0022578125 1.055902e-05 0.0027578125 1.0563e-05 0.0027578125 1.056302e-05 0.0032578125 1.0567e-05 0.0032578125 1.056702e-05 0.0007578125 1.0571e-05 0.0007578125 1.057102e-05 0.0020078125 1.0575e-05 0.0020078125 1.057502e-05 0.0012578125 1.0579e-05 0.0012578125 \
1.057902e-05 0.0015078125 1.0583e-05 0.0015078125 1.058302e-05 0.0017578125 1.0587e-05 0.0017578125 1.058702e-05 0.0022578125 1.0591e-05 0.0022578125 1.059102e-05 0.0002578125 1.0595e-05 0.0002578125 1.059502e-05 0.0002578125 1.0599e-05 0.0002578125 1.059902e-05 0.0032578125 1.0603e-05 0.0032578125 \
1.060302e-05 0.0017578125 1.0607e-05 0.0017578125 1.060702e-05 0.0027578125 1.0611e-05 0.0027578125 1.061102e-05 0.0020078125 1.0615e-05 0.0020078125 1.061502e-05 0.0022578125 1.0619e-05 0.0022578125 1.061902e-05 0.0015078125 1.0623e-05 0.0015078125 1.062302e-05 0.0007578125 1.0627e-05 0.0007578125 \
1.062702e-05 0.0012578125 1.0631e-05 0.0012578125 1.063102e-05 0.0015078125 1.0635e-05 0.0015078125 1.063502e-05 0.0007578125 1.0639e-05 0.0007578125 1.063902e-05 0.0022578125 1.0643e-05 0.0022578125 1.064302e-05 0.0012578125 1.0647e-05 0.0012578125 1.064702e-05 0.0020078125 1.0651e-05 0.0020078125 \
1.065102e-05 0.0002578125 1.0655e-05 0.0002578125 1.065502e-05 0.0027578125 1.0659e-05 0.0027578125 1.065902e-05 0.0032578125 1.0663e-05 0.0032578125 1.066302e-05 0.0017578125 1.0667e-05 0.0017578125 1.066702e-05 0.0017578125 1.0671e-05 0.0017578125 1.067102e-05 0.0015078125 1.0675e-05 0.0015078125 \
1.067502e-05 0.0012578125 1.0679e-05 0.0012578125 1.067902e-05 0.0022578125 1.0683e-05 0.0022578125 1.068302e-05 0.0032578125 1.0687e-05 0.0032578125 1.068702e-05 0.0020078125 1.0691e-05 0.0020078125 1.069102e-05 0.0007578125 1.0695e-05 0.0007578125 1.069502e-05 0.0002578125 1.0699e-05 0.0002578125 \
1.069902e-05 0.0027578125 1.0703e-05 0.0027578125 1.070302e-05 0.0007578125 1.0707e-05 0.0007578125 1.070702e-05 0.0027578125 1.0711e-05 0.0027578125 1.071102e-05 0.0002578125 1.0715e-05 0.0002578125 1.071502e-05 0.0012578125 1.0719e-05 0.0012578125 1.071902e-05 0.0022578125 1.0723e-05 0.0022578125 \
1.072302e-05 0.0020078125 1.0727e-05 0.0020078125 1.072702e-05 0.0017578125 1.0731e-05 0.0017578125 1.073102e-05 0.0032578125 1.0735e-05 0.0032578125 1.073502e-05 0.0015078125 1.0739e-05 0.0015078125 1.073902e-05 0.0007578125 1.0743e-05 0.0007578125 1.074302e-05 0.0020078125 1.0747e-05 0.0020078125 \
1.074702e-05 0.0015078125 1.0751e-05 0.0015078125 1.075102e-05 0.0002578125 1.0755e-05 0.0002578125 1.075502e-05 0.0032578125 1.0759e-05 0.0032578125 1.075902e-05 0.0027578125 1.0763e-05 0.0027578125 1.076302e-05 0.0012578125 1.0767e-05 0.0012578125 1.076702e-05 0.0022578125 1.0771e-05 0.0022578125 \
1.077102e-05 0.0017578125 1.0775e-05 0.0017578125 1.077502e-05 0.0007578125 1.0779e-05 0.0007578125 1.077902e-05 0.0017578125 1.0783e-05 0.0017578125 1.078302e-05 0.0002578125 1.0787e-05 0.0002578125 1.078702e-05 0.0015078125 1.0791e-05 0.0015078125 1.079102e-05 0.0012578125 1.0795e-05 0.0012578125 \
1.079502e-05 0.0027578125 1.0799e-05 0.0027578125 1.079902e-05 0.0020078125 1.0803e-05 0.0020078125 1.080302e-05 0.0022578125 1.0807e-05 0.0022578125 1.080702e-05 0.0032578125 1.0811e-05 0.0032578125 1.081102e-05 0.0017578125 1.0815e-05 0.0017578125 1.081502e-05 0.0015078125 1.0819e-05 0.0015078125 \
1.081902e-05 0.0032578125 1.0823e-05 0.0032578125 1.082302e-05 0.0002578125 1.0827e-05 0.0002578125 1.082702e-05 0.0022578125 1.0831e-05 0.0022578125 1.083102e-05 0.0012578125 1.0835e-05 0.0012578125 1.083502e-05 0.0020078125 1.0839e-05 0.0020078125 1.083902e-05 0.0007578125 1.0843e-05 0.0007578125 \
1.084302e-05 0.0027578125 1.0847e-05 0.0027578125 1.084702e-05 0.0020078125 1.0851e-05 0.0020078125 1.085102e-05 0.0012578125 1.0855e-05 0.0012578125 1.085502e-05 0.0002578125 1.0859e-05 0.0002578125 1.085902e-05 0.0032578125 1.0863e-05 0.0032578125 1.086302e-05 0.0007578125 1.0867e-05 0.0007578125 \
1.086702e-05 0.0022578125 1.0871e-05 0.0022578125 1.087102e-05 0.0027578125 1.0875e-05 0.0027578125 1.087502e-05 0.0015078125 1.0879e-05 0.0015078125 1.087902e-05 0.0017578125 1.0883e-05 0.0017578125 1.088302e-05 0.0012578125 1.0887e-05 0.0012578125 1.088702e-05 0.0015078125 1.0891e-05 0.0015078125 \
1.089102e-05 0.0020078125 1.0895e-05 0.0020078125 1.089502e-05 0.0022578125 1.0899e-05 0.0022578125 1.089902e-05 0.0002578125 1.0903e-05 0.0002578125 1.090302e-05 0.0017578125 1.0907e-05 0.0017578125 1.090702e-05 0.0027578125 1.0911e-05 0.0027578125 1.091102e-05 0.0007578125 1.0915e-05 0.0007578125 \
1.091502e-05 0.0032578125 1.0919e-05 0.0032578125 1.091902e-05 0.0020078125 1.0923e-05 0.0020078125 1.092302e-05 0.0007578125 1.0927e-05 0.0007578125 1.092702e-05 0.0022578125 1.0931e-05 0.0022578125 1.093102e-05 0.0027578125 1.0935e-05 0.0027578125 1.093502e-05 0.0032578125 1.0939e-05 0.0032578125 \
1.093902e-05 0.0002578125 1.0943e-05 0.0002578125 1.094302e-05 0.0012578125 1.0947e-05 0.0012578125 1.094702e-05 0.0017578125 1.0951e-05 0.0017578125 1.095102e-05 0.0015078125 1.0955e-05 0.0015078125 1.095502e-05 0.0002578125 1.0959e-05 0.0002578125 1.095902e-05 0.0007578125 1.0963e-05 0.0007578125 \
1.096302e-05 0.0015078125 1.0967e-05 0.0015078125 1.096702e-05 0.0012578125 1.0971e-05 0.0012578125 1.097102e-05 0.0017578125 1.0975e-05 0.0017578125 1.097502e-05 0.0020078125 1.0979e-05 0.0020078125 1.097902e-05 0.0027578125 1.0983e-05 0.0027578125 1.098302e-05 0.0022578125 1.0987e-05 0.0022578125 \
1.098702e-05 0.0032578125 1.0991e-05 0.0032578125 1.099102e-05 0.0017578125 1.0995e-05 0.0017578125 1.099502e-05 0.0012578125 1.0999e-05 0.0012578125 1.099902e-05 0.0020078125 1.1003e-05 0.0020078125 1.100302e-05 0.0015078125 1.1007e-05 0.0015078125 1.100702e-05 0.0022578125 1.1011e-05 0.0022578125 \
1.101102e-05 0.0027578125 1.1015e-05 0.0027578125 1.101502e-05 0.0032578125 1.1019e-05 0.0032578125 1.101902e-05 0.0002578125 1.1023e-05 0.0002578125 1.102302e-05 0.0007578125 1.1027e-05 0.0007578125 1.102702e-05 0.0017578125 1.1031e-05 0.0017578125 1.103102e-05 0.0020078125 1.1035e-05 0.0020078125 \
1.103502e-05 0.0027578125 1.1039e-05 0.0027578125 1.103902e-05 0.0012578125 1.1043e-05 0.0012578125 1.104302e-05 0.0032578125 1.1047e-05 0.0032578125 1.104702e-05 0.0022578125 1.1051e-05 0.0022578125 1.105102e-05 0.0007578125 1.1055e-05 0.0007578125 1.105502e-05 0.0015078125 1.1059e-05 0.0015078125 \
1.105902e-05 0.0002578125 1.1063e-05 0.0002578125 1.106302e-05 0.0020078125 1.1067e-05 0.0020078125 1.106702e-05 0.0017578125 1.1071e-05 0.0017578125 1.107102e-05 0.0007578125 1.1075e-05 0.0007578125 1.107502e-05 0.0012578125 1.1079e-05 0.0012578125 1.107902e-05 0.0002578125 1.1083e-05 0.0002578125 \
1.108302e-05 0.0015078125 1.1087e-05 0.0015078125 1.108702e-05 0.0022578125 1.1091e-05 0.0022578125 1.109102e-05 0.0027578125 1.1095e-05 0.0027578125 1.109502e-05 0.0032578125 1.1099e-05 0.0032578125 1.109902e-05 0.0015078125 1.1103e-05 0.0015078125 1.110302e-05 0.0022578125 1.1107e-05 0.0022578125 \
1.110702e-05 0.0027578125 1.1111e-05 0.0027578125 1.111102e-05 0.0017578125 1.1115e-05 0.0017578125 1.111502e-05 0.0032578125 1.1119e-05 0.0032578125 1.111902e-05 0.0002578125 1.1123e-05 0.0002578125 1.112302e-05 0.0020078125 1.1127e-05 0.0020078125 1.112702e-05 0.0007578125 1.1131e-05 0.0007578125 \
1.113102e-05 0.0012578125 1.1135e-05 0.0012578125 1.113502e-05 0.0022578125 1.1139e-05 0.0022578125 1.113902e-05 0.0007578125 1.1143e-05 0.0007578125 1.114302e-05 0.0020078125 1.1147e-05 0.0020078125 1.114702e-05 0.0027578125 1.1151e-05 0.0027578125 1.115102e-05 0.0012578125 1.1155e-05 0.0012578125 \
1.115502e-05 0.0032578125 1.1159e-05 0.0032578125 1.115902e-05 0.0002578125 1.1163e-05 0.0002578125 1.116302e-05 0.0017578125 1.1167e-05 0.0017578125 1.116702e-05 0.0015078125 1.1171e-05 0.0015078125 1.117102e-05 0.0012578125 1.1175e-05 0.0012578125 1.117502e-05 0.0022578125 1.1179e-05 0.0022578125 \
1.117902e-05 0.0032578125 1.1183e-05 0.0032578125 1.118302e-05 0.0027578125 1.1187e-05 0.0027578125 1.118702e-05 0.0020078125 1.1191e-05 0.0020078125 1.119102e-05 0.0015078125 1.1195e-05 0.0015078125 1.119502e-05 0.0017578125 1.1199e-05 0.0017578125 1.119902e-05 0.0007578125 1.1203e-05 0.0007578125 \
1.120302e-05 0.0002578125 1.1207e-05 0.0002578125 1.120702e-05 0.0012578125 1.1211e-05 0.0012578125 1.121102e-05 0.0020078125 1.1215e-05 0.0020078125 1.121502e-05 0.0017578125 1.1219e-05 0.0017578125 1.121902e-05 0.0007578125 1.1223e-05 0.0007578125 1.122302e-05 0.0015078125 1.1227e-05 0.0015078125 \
1.122702e-05 0.0027578125 1.1231e-05 0.0027578125 1.123102e-05 0.0032578125 1.1235e-05 0.0032578125 1.123502e-05 0.0002578125 1.1239e-05 0.0002578125 1.123902e-05 0.0022578125 1.1243e-05 0.0022578125 1.124302e-05 0.0017578125 1.1247e-05 0.0017578125 1.124702e-05 0.0007578125 1.1251e-05 0.0007578125 \
1.125102e-05 0.0002578125 1.1255e-05 0.0002578125 1.125502e-05 0.0032578125 1.1259e-05 0.0032578125 1.125902e-05 0.0020078125 1.1263e-05 0.0020078125 1.126302e-05 0.0015078125 1.1267e-05 0.0015078125 1.126702e-05 0.0012578125 1.1271e-05 0.0012578125 1.127102e-05 0.0022578125 1.1275e-05 0.0022578125 \
1.127502e-05 0.0027578125 1.1279e-05 0.0027578125 1.127902e-05 0.0012578125 1.1283e-05 0.0012578125 1.128302e-05 0.0027578125 1.1287e-05 0.0027578125 1.128702e-05 0.0002578125 1.1291e-05 0.0002578125 1.129102e-05 0.0017578125 1.1295e-05 0.0017578125 1.129502e-05 0.0032578125 1.1299e-05 0.0032578125 \
1.129902e-05 0.0022578125 1.1303e-05 0.0022578125 1.130302e-05 0.0015078125 1.1307e-05 0.0015078125 1.130702e-05 0.0020078125 1.1311e-05 0.0020078125 1.131102e-05 0.0007578125 1.1315e-05 0.0007578125 1.131502e-05 0.0017578125 1.1319e-05 0.0017578125 1.131902e-05 0.0020078125 1.1323e-05 0.0020078125 \
1.132302e-05 0.0032578125 1.1327e-05 0.0032578125 1.132702e-05 0.0012578125 1.1331e-05 0.0012578125 1.133102e-05 0.0007578125 1.1335e-05 0.0007578125 1.133502e-05 0.0022578125 1.1339e-05 0.0022578125 1.133902e-05 0.0002578125 1.1343e-05 0.0002578125 1.134302e-05 0.0015078125 1.1347e-05 0.0015078125 \
1.134702e-05 0.0027578125 1.1351e-05 0.0027578125 1.135102e-05 0.0002578125 1.1355e-05 0.0002578125 1.135502e-05 0.0017578125 1.1359e-05 0.0017578125 1.135902e-05 0.0027578125 1.1363e-05 0.0027578125 1.136302e-05 0.0022578125 1.1367e-05 0.0022578125 1.136702e-05 0.0032578125 1.1371e-05 0.0032578125 \
1.137102e-05 0.0007578125 1.1375e-05 0.0007578125 1.137502e-05 0.0020078125 1.1379e-05 0.0020078125 1.137902e-05 0.0012578125 1.1383e-05 0.0012578125 1.138302e-05 0.0015078125 1.1387e-05 0.0015078125 1.138702e-05 0.0015078125 1.1391e-05 0.0015078125 1.139102e-05 0.0002578125 1.1395e-05 0.0002578125 \
1.139502e-05 0.0012578125 1.1399e-05 0.0012578125 1.139902e-05 0.0027578125 1.1403e-05 0.0027578125 1.140302e-05 0.0007578125 1.1407e-05 0.0007578125 1.140702e-05 0.0032578125 1.1411e-05 0.0032578125 1.141102e-05 0.0022578125 1.1415e-05 0.0022578125 1.141502e-05 0.0020078125 1.1419e-05 0.0020078125 \
1.141902e-05 0.0017578125 1.1423e-05 0.0017578125 1.142302e-05 0.0012578125 1.1427e-05 0.0012578125 1.142702e-05 0.0002578125 1.1431e-05 0.0002578125 1.143102e-05 0.0007578125 1.1435e-05 0.0007578125 1.143502e-05 0.0020078125 1.1439e-05 0.0020078125 1.143902e-05 0.0022578125 1.1443e-05 0.0022578125 \
1.144302e-05 0.0017578125 1.1447e-05 0.0017578125 1.144702e-05 0.0032578125 1.1451e-05 0.0032578125 1.145102e-05 0.0027578125 1.1455e-05 0.0027578125 1.145502e-05 0.0015078125 1.1459e-05 0.0015078125 1.145902e-05 0.0002578125 1.1463e-05 0.0002578125 1.146302e-05 0.0015078125 1.1467e-05 0.0015078125 \
1.146702e-05 0.0022578125 1.1471e-05 0.0022578125 1.147102e-05 0.0032578125 1.1475e-05 0.0032578125 1.147502e-05 0.0027578125 1.1479e-05 0.0027578125 1.147902e-05 0.0017578125 1.1483e-05 0.0017578125 1.148302e-05 0.0020078125 1.1487e-05 0.0020078125 1.148702e-05 0.0012578125 1.1491e-05 0.0012578125 \
1.149102e-05 0.0007578125 1.1495e-05 0.0007578125 1.149502e-05 0.0027578125 1.1499e-05 0.0027578125 1.149902e-05 0.0032578125 1.1503e-05 0.0032578125 1.150302e-05 0.0020078125 1.1507e-05 0.0020078125 1.150702e-05 0.0015078125 1.1511e-05 0.0015078125 1.151102e-05 0.0002578125 1.1515e-05 0.0002578125 \
1.151502e-05 0.0022578125 1.1519e-05 0.0022578125 1.151902e-05 0.0017578125 1.1523e-05 0.0017578125 1.152302e-05 0.0007578125 1.1527e-05 0.0007578125 1.152702e-05 0.0012578125 1.1531e-05 0.0012578125 1.153102e-05 0.0032578125 1.1535e-05 0.0032578125 1.153502e-05 0.0015078125 1.1539e-05 0.0015078125 \
1.153902e-05 0.0017578125 1.1543e-05 0.0017578125 1.154302e-05 0.0002578125 1.1547e-05 0.0002578125 1.154702e-05 0.0022578125 1.1551e-05 0.0022578125 1.155102e-05 0.0020078125 1.1555e-05 0.0020078125 1.155502e-05 0.0027578125 1.1559e-05 0.0027578125 1.155902e-05 0.0007578125 1.1563e-05 0.0007578125 \
1.156302e-05 0.0012578125 1.1567e-05 0.0012578125 1.156702e-05 0.0017578125 1.1571e-05 0.0017578125 1.157102e-05 0.0032578125 1.1575e-05 0.0032578125 1.157502e-05 0.0007578125 1.1579e-05 0.0007578125 1.157902e-05 0.0002578125 1.1583e-05 0.0002578125 1.158302e-05 0.0022578125 1.1587e-05 0.0022578125 \
1.158702e-05 0.0020078125 1.1591e-05 0.0020078125 1.159102e-05 0.0015078125 1.1595e-05 0.0015078125 1.159502e-05 0.0027578125 1.1599e-05 0.0027578125 1.159902e-05 0.0012578125 1.1603e-05 0.0012578125 1.160302e-05 0.0017578125 1.1607e-05 0.0017578125 1.160702e-05 0.0027578125 1.1611e-05 0.0027578125 \
1.161102e-05 0.0002578125 1.1615e-05 0.0002578125 1.161502e-05 0.0012578125 1.1619e-05 0.0012578125 1.161902e-05 0.0007578125 1.1623e-05 0.0007578125 1.162302e-05 0.0015078125 1.1627e-05 0.0015078125 1.162702e-05 0.0020078125 1.1631e-05 0.0020078125 1.163102e-05 0.0032578125 1.1635e-05 0.0032578125 \
1.163502e-05 0.0022578125 1.1639e-05 0.0022578125 1.163902e-05 0.0015078125 1.1643e-05 0.0015078125 1.164302e-05 0.0027578125 1.1647e-05 0.0027578125 1.164702e-05 0.0022578125 1.1651e-05 0.0022578125 1.165102e-05 0.0020078125 1.1655e-05 0.0020078125 1.165502e-05 0.0002578125 1.1659e-05 0.0002578125 \
1.165902e-05 0.0032578125 1.1663e-05 0.0032578125 1.166302e-05 0.0007578125 1.1667e-05 0.0007578125 1.166702e-05 0.0012578125 1.1671e-05 0.0012578125 1.167102e-05 0.0017578125 1.1675e-05 0.0017578125 1.167502e-05 0.0022578125 1.1679e-05 0.0022578125 1.167902e-05 0.0015078125 1.1683e-05 0.0015078125 \
1.168302e-05 0.0017578125 1.1687e-05 0.0017578125 1.168702e-05 0.0002578125 1.1691e-05 0.0002578125 1.169102e-05 0.0032578125 1.1695e-05 0.0032578125 1.169502e-05 0.0012578125 1.1699e-05 0.0012578125 1.169902e-05 0.0020078125 1.1703e-05 0.0020078125 1.170302e-05 0.0027578125 1.1707e-05 0.0027578125 \
1.170702e-05 0.0007578125 1.1711e-05 0.0007578125 1.171102e-05 0.0012578125 1.1715e-05 0.0012578125 1.171502e-05 0.0022578125 1.1719e-05 0.0022578125 1.171902e-05 0.0002578125 1.1723e-05 0.0002578125 1.172302e-05 0.0007578125 1.1727e-05 0.0007578125 1.172702e-05 0.0032578125 1.1731e-05 0.0032578125 \
1.173102e-05 0.0027578125 1.1735e-05 0.0027578125 1.173502e-05 0.0015078125 1.1739e-05 0.0015078125 1.173902e-05 0.0020078125 1.1743e-05 0.0020078125 1.174302e-05 0.0017578125 1.1747e-05 0.0017578125 1.174702e-05 0.0007578125 1.1751e-05 0.0007578125 1.175102e-05 0.0020078125 1.1755e-05 0.0020078125 \
1.175502e-05 0.0032578125 1.1759e-05 0.0032578125 1.175902e-05 0.0017578125 1.1763e-05 0.0017578125 1.176302e-05 0.0027578125 1.1767e-05 0.0027578125 1.176702e-05 0.0002578125 1.1771e-05 0.0002578125 1.177102e-05 0.0022578125 1.1775e-05 0.0022578125 1.177502e-05 0.0012578125 1.1779e-05 0.0012578125 \
1.177902e-05 0.0015078125 1.1783e-05 0.0015078125 1.178302e-05 0.0015078125 1.1787e-05 0.0015078125 1.178702e-05 0.0022578125 1.1791e-05 0.0022578125 1.179102e-05 0.0012578125 1.1795e-05 0.0012578125 1.179502e-05 0.0020078125 1.1799e-05 0.0020078125 1.179902e-05 0.0002578125 1.1803e-05 0.0002578125 \
1.180302e-05 0.0017578125 1.1807e-05 0.0017578125 1.180702e-05 0.0007578125 1.1811e-05 0.0007578125 1.181102e-05 0.0027578125 1.1815e-05 0.0027578125 1.181502e-05 0.0032578125 1.1819e-05 0.0032578125 1.181902e-05 0.0022578125 1.1823e-05 0.0022578125 1.182302e-05 0.0017578125 1.1827e-05 0.0017578125 \
1.182702e-05 0.0012578125 1.1831e-05 0.0012578125 1.183102e-05 0.0007578125 1.1835e-05 0.0007578125 1.183502e-05 0.0020078125 1.1839e-05 0.0020078125 1.183902e-05 0.0032578125 1.1843e-05 0.0032578125 1.184302e-05 0.0027578125 1.1847e-05 0.0027578125 1.184702e-05 0.0015078125 1.1851e-05 0.0015078125 \
1.185102e-05 0.0002578125 1.1855e-05 0.0002578125 1.185502e-05 0.0012578125 1.1859e-05 0.0012578125 1.185902e-05 0.0017578125 1.1863e-05 0.0017578125 1.186302e-05 0.0015078125 1.1867e-05 0.0015078125 1.186702e-05 0.0020078125 1.1871e-05 0.0020078125 1.187102e-05 0.0032578125 1.1875e-05 0.0032578125 \
1.187502e-05 0.0022578125 1.1879e-05 0.0022578125 1.187902e-05 0.0027578125 1.1883e-05 0.0027578125 1.188302e-05 0.0002578125 1.1887e-05 0.0002578125 1.188702e-05 0.0007578125 1.1891e-05 0.0007578125 1.189102e-05 0.0017578125 1.1895e-05 0.0017578125 1.189502e-05 0.0020078125 1.1899e-05 0.0020078125 \
1.189902e-05 0.0032578125 1.1903e-05 0.0032578125 1.190302e-05 0.0015078125 1.1907e-05 0.0015078125 1.190702e-05 0.0022578125 1.1911e-05 0.0022578125 1.191102e-05 0.0027578125 1.1915e-05 0.0027578125 1.191502e-05 0.0012578125 1.1919e-05 0.0012578125 1.191902e-05 0.0007578125 1.1923e-05 0.0007578125 \
1.192302e-05 0.0002578125 1.1927e-05 0.0002578125 1.192702e-05 0.0007578125 1.1931e-05 0.0007578125 1.193102e-05 0.0020078125 1.1935e-05 0.0020078125 1.193502e-05 0.0027578125 1.1939e-05 0.0027578125 1.193902e-05 0.0012578125 1.1943e-05 0.0012578125 1.194302e-05 0.0002578125 1.1947e-05 0.0002578125 \
1.194702e-05 0.0022578125 1.1951e-05 0.0022578125 1.195102e-05 0.0032578125 1.1955e-05 0.0032578125 1.195502e-05 0.0015078125 1.1959e-05 0.0015078125 1.195902e-05 0.0017578125 1.1963e-05 0.0017578125 1.196302e-05 0.0020078125 1.1967e-05 0.0020078125 1.196702e-05 0.0007578125 1.1971e-05 0.0007578125 \
1.197102e-05 0.0012578125 1.1975e-05 0.0012578125 1.197502e-05 0.0002578125 1.1979e-05 0.0002578125 1.197902e-05 0.0015078125 1.1983e-05 0.0015078125 1.198302e-05 0.0027578125 1.1987e-05 0.0027578125 1.198702e-05 0.0032578125 1.1991e-05 0.0032578125 1.199102e-05 0.0022578125 1.1995e-05 0.0022578125 \
1.199502e-05 0.0017578125 1.1999e-05 0.0017578125 1.199902e-05 0.0012578125 1.2003e-05 0.0012578125 1.200302e-05 0.0007578125 1.2007e-05 0.0007578125 1.200702e-05 0.0027578125 1.2011e-05 0.0027578125 1.201102e-05 0.0002578125 1.2015e-05 0.0002578125 1.201502e-05 0.0017578125 1.2019e-05 0.0017578125 \
1.201902e-05 0.0032578125 1.2023e-05 0.0032578125 1.202302e-05 0.0022578125 1.2027e-05 0.0022578125 1.202702e-05 0.0015078125 1.2031e-05 0.0015078125 1.203102e-05 0.0020078125 1.2035e-05 0.0020078125 1.203502e-05 0.0002578125 1.2039e-05 0.0002578125 1.203902e-05 0.0032578125 1.2043e-05 0.0032578125 \
1.204302e-05 0.0022578125 1.2047e-05 0.0022578125 1.204702e-05 0.0020078125 1.2051e-05 0.0020078125 1.205102e-05 0.0012578125 1.2055e-05 0.0012578125 1.205502e-05 0.0017578125 1.2059e-05 0.0017578125 1.205902e-05 0.0007578125 1.2063e-05 0.0007578125 1.206302e-05 0.0027578125 1.2067e-05 0.0027578125 \
1.206702e-05 0.0015078125 1.2071e-05 0.0015078125 1.207102e-05 0.0027578125 1.2075e-05 0.0027578125 1.207502e-05 0.0032578125 1.2079e-05 0.0032578125 1.207902e-05 0.0015078125 1.2083e-05 0.0015078125 1.208302e-05 0.0007578125 1.2087e-05 0.0007578125 1.208702e-05 0.0002578125 1.2091e-05 0.0002578125 \
1.209102e-05 0.0012578125 1.2095e-05 0.0012578125 1.209502e-05 0.0022578125 1.2099e-05 0.0022578125 1.209902e-05 0.0017578125 1.2103e-05 0.0017578125 1.210302e-05 0.0020078125 1.2107e-05 0.0020078125 1.210702e-05 0.0022578125 1.2111e-05 0.0022578125 1.211102e-05 0.0007578125 1.2115e-05 0.0007578125 \
1.211502e-05 0.0027578125 1.2119e-05 0.0027578125 1.211902e-05 0.0032578125 1.2123e-05 0.0032578125 1.212302e-05 0.0002578125 1.2127e-05 0.0002578125 1.212702e-05 0.0012578125 1.2131e-05 0.0012578125 1.213102e-05 0.0020078125 1.2135e-05 0.0020078125 1.213502e-05 0.0015078125 1.2139e-05 0.0015078125 \
1.213902e-05 0.0017578125 1.2143e-05 0.0017578125 1.214302e-05 0.0007578125 1.2147e-05 0.0007578125 1.214702e-05 0.0032578125 1.2151e-05 0.0032578125 1.215102e-05 0.0012578125 1.2155e-05 0.0012578125 1.215502e-05 0.0017578125 1.2159e-05 0.0017578125 1.215902e-05 0.0022578125 1.2163e-05 0.0022578125 \
1.216302e-05 0.0002578125 1.2167e-05 0.0002578125 1.216702e-05 0.0020078125 1.2171e-05 0.0020078125 1.217102e-05 0.0027578125 1.2175e-05 0.0027578125 1.217502e-05 0.0015078125 1.2179e-05 0.0015078125 1.217902e-05 0.0017578125 1.2183e-05 0.0017578125 1.218302e-05 0.0002578125 1.2187e-05 0.0002578125 \
1.218702e-05 0.0027578125 1.2191e-05 0.0027578125 1.219102e-05 0.0020078125 1.2195e-05 0.0020078125 1.219502e-05 0.0007578125 1.2199e-05 0.0007578125 1.219902e-05 0.0032578125 1.2203e-05 0.0032578125 1.220302e-05 0.0022578125 1.2207e-05 0.0022578125 1.220702e-05 0.0015078125 1.2211e-05 0.0015078125 \
1.221102e-05 0.0012578125 1.2215e-05 0.0012578125 1.221502e-05 0.0007578125 1.2219e-05 0.0007578125 1.221902e-05 0.0017578125 1.2223e-05 0.0017578125 1.222302e-05 0.0015078125 1.2227e-05 0.0015078125 1.222702e-05 0.0020078125 1.2231e-05 0.0020078125 1.223102e-05 0.0002578125 1.2235e-05 0.0002578125 \
1.223502e-05 0.0022578125 1.2239e-05 0.0022578125 1.223902e-05 0.0012578125 1.2243e-05 0.0012578125 1.224302e-05 0.0032578125 1.2247e-05 0.0032578125 1.224702e-05 0.0027578125 1.2251e-05 0.0027578125 1.225102e-05 0.0017578125 1.2255e-05 0.0017578125 1.225502e-05 0.0020078125 1.2259e-05 0.0020078125 \
1.225902e-05 0.0007578125 1.2263e-05 0.0007578125 1.226302e-05 0.0012578125 1.2267e-05 0.0012578125 1.226702e-05 0.0015078125 1.2271e-05 0.0015078125 1.227102e-05 0.0002578125 1.2275e-05 0.0002578125 1.227502e-05 0.0022578125 1.2279e-05 0.0022578125 1.227902e-05 0.0027578125 1.2283e-05 0.0027578125 \
1.228302e-05 0.0032578125 1.2287e-05 0.0032578125 1.228702e-05 0.0007578125 1.2291e-05 0.0007578125 1.229102e-05 0.0012578125 1.2295e-05 0.0012578125 1.229502e-05 0.0032578125 1.2299e-05 0.0032578125 1.229902e-05 0.0017578125 1.2303e-05 0.0017578125 1.230302e-05 0.0015078125 1.2307e-05 0.0015078125 \
1.230702e-05 0.0020078125 1.2311e-05 0.0020078125 1.231102e-05 0.0022578125 1.2315e-05 0.0022578125 1.231502e-05 0.0027578125 1.2319e-05 0.0027578125 1.231902e-05 0.0002578125 1.2323e-05 0.0002578125 1.232302e-05 0.0027578125 1.2327e-05 0.0027578125 1.232702e-05 0.0022578125 1.2331e-05 0.0022578125 \
1.233102e-05 0.0032578125 1.2335e-05 0.0032578125 1.233502e-05 0.0017578125 1.2339e-05 0.0017578125 1.233902e-05 0.0002578125 1.2343e-05 0.0002578125 1.234302e-05 0.0007578125 1.2347e-05 0.0007578125 1.234702e-05 0.0015078125 1.2351e-05 0.0015078125 1.235102e-05 0.0012578125 1.2355e-05 0.0012578125 \
1.235502e-05 0.0020078125 1.2359e-05 0.0020078125 1.235902e-05 0.0032578125 1.2363e-05 0.0032578125 1.236302e-05 0.0017578125 1.2367e-05 0.0017578125 1.236702e-05 0.0002578125 1.2371e-05 0.0002578125 1.237102e-05 0.0015078125 1.2375e-05 0.0015078125 1.237502e-05 0.0022578125 1.2379e-05 0.0022578125 \
1.237902e-05 0.0007578125 1.2383e-05 0.0007578125 1.238302e-05 0.0012578125 1.2387e-05 0.0012578125 1.238702e-05 0.0027578125 1.2391e-05 0.0027578125 1.239102e-05 0.0020078125 1.2395e-05 0.0020078125 1.239502e-05 0.0020078125 1.2399e-05 0.0020078125 1.239902e-05 0.0027578125 1.2403e-05 0.0027578125 \
1.240302e-05 0.0022578125 1.2407e-05 0.0022578125 1.240702e-05 0.0007578125 1.2411e-05 0.0007578125 1.241102e-05 0.0032578125 1.2415e-05 0.0032578125 1.241502e-05 0.0012578125 1.2419e-05 0.0012578125 1.241902e-05 0.0002578125 1.2423e-05 0.0002578125 1.242302e-05 0.0015078125 1.2427e-05 0.0015078125 \
1.242702e-05 0.0017578125 1.2431e-05 0.0017578125 1.243102e-05 0.0032578125 1.2435e-05 0.0032578125 1.243502e-05 0.0012578125 1.2439e-05 0.0012578125 1.243902e-05 0.0002578125 1.2443e-05 0.0002578125 1.244302e-05 0.0027578125 1.2447e-05 0.0027578125 1.244702e-05 0.0022578125 1.2451e-05 0.0022578125 \
1.245102e-05 0.0020078125 1.2455e-05 0.0020078125 1.245502e-05 0.0017578125 1.2459e-05 0.0017578125 1.245902e-05 0.0007578125 1.2463e-05 0.0007578125 1.246302e-05 0.0015078125 1.2467e-05 0.0015078125 1.246702e-05 0.0032578125 1.2471e-05 0.0032578125 1.247102e-05 0.0002578125 1.2475e-05 0.0002578125 \
1.247502e-05 0.0022578125 1.2479e-05 0.0022578125 1.247902e-05 0.0015078125 1.2483e-05 0.0015078125 1.248302e-05 0.0007578125 1.2487e-05 0.0007578125 1.248702e-05 0.0017578125 1.2491e-05 0.0017578125 1.249102e-05 0.0012578125 1.2495e-05 0.0012578125 1.249502e-05 0.0027578125 1.2499e-05 0.0027578125 \
1.249902e-05 0.0020078125 1.2503e-05 0.0020078125 1.250302e-05 0.0012578125 1.2507e-05 0.0012578125 1.250702e-05 0.0027578125 1.2511e-05 0.0027578125 1.251102e-05 0.0007578125 1.2515e-05 0.0007578125 1.251502e-05 0.0032578125 1.2519e-05 0.0032578125 1.251902e-05 0.0002578125 1.2523e-05 0.0002578125 \
1.252302e-05 0.0015078125 1.2527e-05 0.0015078125 1.252702e-05 0.0022578125 1.2531e-05 0.0022578125 1.253102e-05 0.0017578125 1.2535e-05 0.0017578125 1.253502e-05 0.0020078125 1.2539e-05 0.0020078125 1.253902e-05 0.0032578125 1.2543e-05 0.0032578125 1.254302e-05 0.0020078125 1.2547e-05 0.0020078125 \
1.254702e-05 0.0012578125 1.2551e-05 0.0012578125 1.255102e-05 0.0022578125 1.2555e-05 0.0022578125 1.255502e-05 0.0017578125 1.2559e-05 0.0017578125 1.255902e-05 0.0027578125 1.2563e-05 0.0027578125 1.256302e-05 0.0015078125 1.2567e-05 0.0015078125 1.256702e-05 0.0007578125 1.2571e-05 0.0007578125 \
1.257102e-05 0.0002578125 1.2575e-05 0.0002578125 1.257502e-05 0.0027578125 1.2579e-05 0.0027578125 1.257902e-05 0.0007578125 1.2583e-05 0.0007578125 1.258302e-05 0.0022578125 1.2587e-05 0.0022578125 1.258702e-05 0.0020078125 1.2591e-05 0.0020078125 1.259102e-05 0.0017578125 1.2595e-05 0.0017578125 \
1.259502e-05 0.0012578125 1.2599e-05 0.0012578125 1.259902e-05 0.0015078125 1.2603e-05 0.0015078125 1.260302e-05 0.0002578125 1.2607e-05 0.0002578125 1.260702e-05 0.0032578125 1.2611e-05 0.0032578125 1.261102e-05 0.0017578125 1.2615e-05 0.0017578125 1.261502e-05 0.0027578125 1.2619e-05 0.0027578125 \
1.261902e-05 0.0022578125 1.2623e-05 0.0022578125 1.262302e-05 0.0032578125 1.2627e-05 0.0032578125 1.262702e-05 0.0012578125 1.2631e-05 0.0012578125 1.263102e-05 0.0002578125 1.2635e-05 0.0002578125 1.263502e-05 0.0007578125 1.2639e-05 0.0007578125 1.263902e-05 0.0015078125 1.2643e-05 0.0015078125 \
1.264302e-05 0.0020078125 1.2647e-05 0.0020078125 1.264702e-05 0.0017578125 1.2651e-05 0.0017578125 1.265102e-05 0.0032578125 1.2655e-05 0.0032578125 1.265502e-05 0.0022578125 1.2659e-05 0.0022578125 1.265902e-05 0.0012578125 1.2663e-05 0.0012578125 1.266302e-05 0.0007578125 1.2667e-05 0.0007578125 \
1.266702e-05 0.0027578125 1.2671e-05 0.0027578125 1.267102e-05 0.0002578125 1.2675e-05 0.0002578125 1.267502e-05 0.0020078125 1.2679e-05 0.0020078125 1.267902e-05 0.0015078125 1.2683e-05 0.0015078125 1.268302e-05 0.0002578125 1.2687e-05 0.0002578125 1.268702e-05 0.0020078125 1.2691e-05 0.0020078125 \
1.269102e-05 0.0015078125 1.2695e-05 0.0015078125 1.269502e-05 0.0012578125 1.2699e-05 0.0012578125 1.269902e-05 0.0017578125 1.2703e-05 0.0017578125 1.270302e-05 0.0032578125 1.2707e-05 0.0032578125 1.270702e-05 0.0007578125 1.2711e-05 0.0007578125 1.271102e-05 0.0027578125 1.2715e-05 0.0027578125 \
1.271502e-05 0.0022578125 1.2719e-05 0.0022578125 1.271902e-05 0.0020078125 1.2723e-05 0.0020078125 1.272302e-05 0.0022578125 1.2727e-05 0.0022578125 1.272702e-05 0.0012578125 1.2731e-05 0.0012578125 1.273102e-05 0.0007578125 1.2735e-05 0.0007578125 1.273502e-05 0.0002578125 1.2739e-05 0.0002578125 \
1.273902e-05 0.0032578125 1.2743e-05 0.0032578125 1.274302e-05 0.0017578125 1.2747e-05 0.0017578125 1.274702e-05 0.0015078125 1.2751e-05 0.0015078125 1.275102e-05 0.0027578125 1.2755e-05 0.0027578125 1.275502e-05 0.0002578125 1.2759e-05 0.0002578125 1.275902e-05 0.0015078125 1.2763e-05 0.0015078125 \
1.276302e-05 0.0022578125 1.2767e-05 0.0022578125 1.276702e-05 0.0012578125 1.2771e-05 0.0012578125 1.277102e-05 0.0020078125 1.2775e-05 0.0020078125 1.277502e-05 0.0017578125 1.2779e-05 0.0017578125 1.277902e-05 0.0027578125 1.2783e-05 0.0027578125 1.278302e-05 0.0032578125 1.2787e-05 0.0032578125 \
1.278702e-05 0.0007578125 1.2791e-05 0.0007578125 1.279102e-05 0.0027578125 1.2795e-05 0.0027578125 1.279502e-05 0.0032578125 1.2799e-05 0.0032578125 1.279902e-05 0.0022578125 1.2803e-05 0.0022578125 1.280302e-05 0.0002578125 1.2807e-05 0.0002578125 1.280702e-05 0.0012578125 1.2811e-05 0.0012578125 \
1.281102e-05 0.0017578125 1.2815e-05 0.0017578125 1.281502e-05 0.0020078125 1.2819e-05 0.0020078125 1.281902e-05 0.0015078125 1.2823e-05 0.0015078125 1.282302e-05 0.0007578125 1.2827e-05 0.0007578125 1.282702e-05 0.0017578125 1.2831e-05 0.0017578125 1.283102e-05 0.0007578125 1.2835e-05 0.0007578125 \
1.283502e-05 0.0022578125 1.2839e-05 0.0022578125 1.283902e-05 0.0020078125 1.2843e-05 0.0020078125 1.284302e-05 0.0002578125 1.2847e-05 0.0002578125 1.284702e-05 0.0027578125 1.2851e-05 0.0027578125 1.285102e-05 0.0032578125 1.2855e-05 0.0032578125 1.285502e-05 0.0012578125 1.2859e-05 0.0012578125 \
1.285902e-05 0.0015078125 1.2863e-05 0.0015078125 1.286302e-05 0.0032578125 1.2867e-05 0.0032578125 1.286702e-05 0.0020078125 1.2871e-05 0.0020078125 1.287102e-05 0.0015078125 1.2875e-05 0.0015078125 1.287502e-05 0.0002578125 1.2879e-05 0.0002578125 1.287902e-05 0.0012578125 1.2883e-05 0.0012578125 \
1.288302e-05 0.0022578125 1.2887e-05 0.0022578125 1.288702e-05 0.0017578125 1.2891e-05 0.0017578125 1.289102e-05 0.0027578125 1.2895e-05 0.0027578125 1.289502e-05 0.0007578125 1.2899e-05 0.0007578125 1.289902e-05 0.0020078125 1.2903e-05 0.0020078125 1.290302e-05 0.0017578125 1.2907e-05 0.0017578125 \
1.290702e-05 0.0027578125 1.2911e-05 0.0027578125 1.291102e-05 0.0022578125 1.2915e-05 0.0022578125 1.291502e-05 0.0012578125 1.2919e-05 0.0012578125 1.291902e-05 0.0007578125 1.2923e-05 0.0007578125 1.292302e-05 0.0032578125 1.2927e-05 0.0032578125 1.292702e-05 0.0002578125 1.2931e-05 0.0002578125 \
1.293102e-05 0.0015078125 1.2935e-05 0.0015078125 1.293502e-05 0.0015078125 1.2939e-05 0.0015078125 1.293902e-05 0.0012578125 1.2943e-05 0.0012578125 1.294302e-05 0.0027578125 1.2947e-05 0.0027578125 1.294702e-05 0.0002578125 1.2951e-05 0.0002578125 1.295102e-05 0.0020078125 1.2955e-05 0.0020078125 \
1.295502e-05 0.0007578125 1.2959e-05 0.0007578125 1.295902e-05 0.0017578125 1.2963e-05 0.0017578125 1.296302e-05 0.0032578125 1.2967e-05 0.0032578125 1.296702e-05 0.0022578125 1.2971e-05 0.0022578125 1.297102e-05 0.0027578125 1.2975e-05 0.0027578125 1.297502e-05 0.0015078125 1.2979e-05 0.0015078125 \
1.297902e-05 0.0002578125 1.2983e-05 0.0002578125 1.298302e-05 0.0020078125 1.2987e-05 0.0020078125 1.298702e-05 0.0007578125 1.2991e-05 0.0007578125 1.299102e-05 0.0032578125 1.2995e-05 0.0032578125 1.299502e-05 0.0022578125 1.2999e-05 0.0022578125 1.299902e-05 0.0017578125 1.3003e-05 0.0017578125 \
1.300302e-05 0.0012578125 1.3007e-05 0.0012578125 1.300702e-05 0.0027578125 1.3011e-05 0.0027578125 1.301102e-05 0.0020078125 1.3015e-05 0.0020078125 1.301502e-05 0.0002578125 1.3019e-05 0.0002578125 1.301902e-05 0.0007578125 1.3023e-05 0.0007578125 1.302302e-05 0.0012578125 1.3027e-05 0.0012578125 \
1.302702e-05 0.0017578125 1.3031e-05 0.0017578125 1.303102e-05 0.0015078125 1.3035e-05 0.0015078125 1.303502e-05 0.0032578125 1.3039e-05 0.0032578125 1.303902e-05 0.0022578125 1.3043e-05 0.0022578125 1.304302e-05 0.0022578125 1.3047e-05 0.0022578125 1.304702e-05 0.0015078125 1.3051e-05 0.0015078125 \
1.305102e-05 0.0020078125 1.3055e-05 0.0020078125 1.305502e-05 0.0007578125 1.3059e-05 0.0007578125 1.305902e-05 0.0027578125 1.3063e-05 0.0027578125 1.306302e-05 0.0032578125 1.3067e-05 0.0032578125 1.306702e-05 0.0017578125 1.3071e-05 0.0017578125 1.307102e-05 0.0012578125 1.3075e-05 0.0012578125 \
1.307502e-05 0.0002578125 1.3079e-05 0.0002578125 1.307902e-05 0.0020078125 1.3083e-05 0.0020078125 1.308302e-05 0.0015078125 1.3087e-05 0.0015078125 1.308702e-05 0.0012578125 1.3091e-05 0.0012578125 1.309102e-05 0.0002578125 1.3095e-05 0.0002578125 1.309502e-05 0.0027578125 1.3099e-05 0.0027578125 \
1.309902e-05 0.0032578125 1.3103e-05 0.0032578125 1.310302e-05 0.0017578125 1.3107e-05 0.0017578125 1.310702e-05 0.0022578125 1.3111e-05 0.0022578125 1.311102e-05 0.0007578125 1.3115e-05 0.0007578125 1.311502e-05 0.0017578125 1.3119e-05 0.0017578125 1.311902e-05 0.0032578125 1.3123e-05 0.0032578125 \
1.312302e-05 0.0020078125 1.3127e-05 0.0020078125 1.312702e-05 0.0022578125 1.3131e-05 0.0022578125 1.313102e-05 0.0027578125 1.3135e-05 0.0027578125 1.313502e-05 0.0007578125 1.3139e-05 0.0007578125 1.313902e-05 0.0002578125 1.3143e-05 0.0002578125 1.314302e-05 0.0015078125 1.3147e-05 0.0015078125 \
1.314702e-05 0.0012578125 1.3151e-05 0.0012578125 1.315102e-05 0.0032578125 1.3155e-05 0.0032578125 1.315502e-05 0.0020078125 1.3159e-05 0.0020078125 1.315902e-05 0.0017578125 1.3163e-05 0.0017578125 1.316302e-05 0.0002578125 1.3167e-05 0.0002578125 1.316702e-05 0.0007578125 1.3171e-05 0.0007578125 \
1.317102e-05 0.0015078125 1.3175e-05 0.0015078125 1.317502e-05 0.0012578125 1.3179e-05 0.0012578125 1.317902e-05 0.0027578125 1.3183e-05 0.0027578125 1.318302e-05 0.0022578125 1.3187e-05 0.0022578125 1.318702e-05 0.0015078125 1.3191e-05 0.0015078125 1.319102e-05 0.0002578125 1.3195e-05 0.0002578125 \
1.319502e-05 0.0012578125 1.3199e-05 0.0012578125 1.319902e-05 0.0020078125 1.3203e-05 0.0020078125 1.320302e-05 0.0032578125 1.3207e-05 0.0032578125 1.320702e-05 0.0022578125 1.3211e-05 0.0022578125 1.321102e-05 0.0007578125 1.3215e-05 0.0007578125 1.321502e-05 0.0027578125 1.3219e-05 0.0027578125 \
1.321902e-05 0.0017578125 1.3223e-05 0.0017578125 1.322302e-05 0.0020078125 1.3227e-05 0.0020078125 1.322702e-05 0.0002578125 1.3231e-05 0.0002578125 1.323102e-05 0.0007578125 1.3235e-05 0.0007578125 1.323502e-05 0.0032578125 1.3239e-05 0.0032578125 1.323902e-05 0.0022578125 1.3243e-05 0.0022578125 \
1.324302e-05 0.0027578125 1.3247e-05 0.0027578125 1.324702e-05 0.0017578125 1.3251e-05 0.0017578125 1.325102e-05 0.0012578125 1.3255e-05 0.0012578125 1.325502e-05 0.0015078125 1.3259e-05 0.0015078125 1.325902e-05 0.0017578125 1.3263e-05 0.0017578125 1.326302e-05 0.0020078125 1.3267e-05 0.0020078125 \
1.326702e-05 0.0027578125 1.3271e-05 0.0027578125 1.327102e-05 0.0032578125 1.3275e-05 0.0032578125 1.327502e-05 0.0015078125 1.3279e-05 0.0015078125 1.327902e-05 0.0002578125 1.3283e-05 0.0002578125 1.328302e-05 0.0022578125 1.3287e-05 0.0022578125 1.328702e-05 0.0007578125 1.3291e-05 0.0007578125 \
1.329102e-05 0.0012578125 1.3295e-05 0.0012578125 1.329502e-05 0.0017578125 1.3299e-05 0.0017578125 1.329902e-05 0.0032578125 1.3303e-05 0.0032578125 1.330302e-05 0.0022578125 1.3307e-05 0.0022578125 1.330702e-05 0.0027578125 1.3311e-05 0.0027578125 1.331102e-05 0.0015078125 1.3315e-05 0.0015078125 \
1.331502e-05 0.0002578125 1.3319e-05 0.0002578125 1.331902e-05 0.0007578125 1.3323e-05 0.0007578125 1.332302e-05 0.0012578125 1.3327e-05 0.0012578125 1.332702e-05 0.0020078125 1.3331e-05 0.0020078125 1.333102e-05 0.0007578125 1.3335e-05 0.0007578125 1.333502e-05 0.0020078125 1.3339e-05 0.0020078125 \
1.333902e-05 0.0022578125 1.3343e-05 0.0022578125 1.334302e-05 0.0012578125 1.3347e-05 0.0012578125 1.334702e-05 0.0032578125 1.3351e-05 0.0032578125 1.335102e-05 0.0015078125 1.3355e-05 0.0015078125 1.335502e-05 0.0017578125 1.3359e-05 0.0017578125 1.335902e-05 0.0002578125 1.3363e-05 0.0002578125 \
1.336302e-05 0.0027578125 1.3367e-05 0.0027578125 1.336702e-05 0.0015078125 1.3371e-05 0.0015078125 1.337102e-05 0.0020078125 1.3375e-05 0.0020078125 1.337502e-05 0.0022578125 1.3379e-05 0.0022578125 1.337902e-05 0.0012578125 1.3383e-05 0.0012578125 1.338302e-05 0.0002578125 1.3387e-05 0.0002578125 \
1.338702e-05 0.0027578125 1.3391e-05 0.0027578125 1.339102e-05 0.0007578125 1.3395e-05 0.0007578125 1.339502e-05 0.0017578125 1.3399e-05 0.0017578125 1.339902e-05 0.0032578125 1.3403e-05 0.0032578125 1.340302e-05 0.0012578125 1.3407e-05 0.0012578125 1.340702e-05 0.0007578125 1.3411e-05 0.0007578125 \
1.341102e-05 0.0027578125 1.3415e-05 0.0027578125 1.341502e-05 0.0022578125 1.3419e-05 0.0022578125 1.341902e-05 0.0015078125 1.3423e-05 0.0015078125 1.342302e-05 0.0002578125 1.3427e-05 0.0002578125 1.342702e-05 0.0032578125 1.3431e-05 0.0032578125 1.343102e-05 0.0017578125 1.3435e-05 0.0017578125 \
1.343502e-05 0.0020078125 1.3439e-05 0.0020078125 1.343902e-05 0.0027578125 1.3443e-05 0.0027578125 1.344302e-05 0.0015078125 1.3447e-05 0.0015078125 1.344702e-05 0.0022578125 1.3451e-05 0.0022578125 1.345102e-05 0.0017578125 1.3455e-05 0.0017578125 1.345502e-05 0.0012578125 1.3459e-05 0.0012578125 \
1.345902e-05 0.0002578125 1.3463e-05 0.0002578125 1.346302e-05 0.0032578125 1.3467e-05 0.0032578125 1.346702e-05 0.0007578125 1.3471e-05 0.0007578125 1.347102e-05 0.0020078125 1.3475e-05 0.0020078125 1.347502e-05 0.0015078125 1.3479e-05 0.0015078125 1.347902e-05 0.0017578125 1.3483e-05 0.0017578125 \
1.348302e-05 0.0002578125 1.3487e-05 0.0002578125 1.348702e-05 0.0027578125 1.3491e-05 0.0027578125 1.349102e-05 0.0022578125 1.3495e-05 0.0022578125 1.349502e-05 0.0032578125 1.3499e-05 0.0032578125 1.349902e-05 0.0020078125 1.3503e-05 0.0020078125 1.350302e-05 0.0007578125 1.3507e-05 0.0007578125 \
1.350702e-05 0.0012578125 1.3511e-05 0.0012578125 1.351102e-05 0.0020078125 1.3515e-05 0.0020078125 1.351502e-05 0.0022578125 1.3519e-05 0.0022578125 1.351902e-05 0.0015078125 1.3523e-05 0.0015078125 1.352302e-05 0.0017578125 1.3527e-05 0.0017578125 1.352702e-05 0.0007578125 1.3531e-05 0.0007578125 \
1.353102e-05 0.0012578125 1.3535e-05 0.0012578125 1.353502e-05 0.0027578125 1.3539e-05 0.0027578125 1.353902e-05 0.0002578125 1.3543e-05 0.0002578125 1.354302e-05 0.0032578125 1.3547e-05 0.0032578125 1.354702e-05 0.0002578125 1.3551e-05 0.0002578125 1.355102e-05 0.0017578125 1.3555e-05 0.0017578125 \
1.355502e-05 0.0027578125 1.3559e-05 0.0027578125 1.355902e-05 0.0007578125 1.3563e-05 0.0007578125 1.356302e-05 0.0020078125 1.3567e-05 0.0020078125 1.356702e-05 0.0032578125 1.3571e-05 0.0032578125 1.357102e-05 0.0015078125 1.3575e-05 0.0015078125 1.357502e-05 0.0022578125 1.3579e-05 0.0022578125 \
1.357902e-05 0.0012578125 1.3583e-05 0.0012578125 1.358302e-05 0.0002578125 1.3587e-05 0.0002578125 1.358702e-05 0.0007578125 1.3591e-05 0.0007578125 1.359102e-05 0.0022578125 1.3595e-05 0.0022578125 1.359502e-05 0.0027578125 1.3599e-05 0.0027578125 1.359902e-05 0.0020078125 1.3603e-05 0.0020078125 \
1.360302e-05 0.0032578125 1.3607e-05 0.0032578125 1.360702e-05 0.0012578125 1.3611e-05 0.0012578125 1.361102e-05 0.0017578125 1.3615e-05 0.0017578125 1.361502e-05 0.0015078125 1.3619e-05 0.0015078125 1.361902e-05 0.0007578125 1.3623e-05 0.0007578125 1.362302e-05 0.0032578125 1.3627e-05 0.0032578125 \
1.362702e-05 0.0027578125 1.3631e-05 0.0027578125 1.363102e-05 0.0017578125 1.3635e-05 0.0017578125 1.363502e-05 0.0012578125 1.3639e-05 0.0012578125 1.363902e-05 0.0015078125 1.3643e-05 0.0015078125 1.364302e-05 0.0022578125 1.3647e-05 0.0022578125 1.364702e-05 0.0002578125 1.3651e-05 0.0002578125 \
1.365102e-05 0.0020078125 1.3655e-05 0.0020078125 1.365502e-05 0.0017578125 1.3659e-05 0.0017578125 1.365902e-05 0.0022578125 1.3663e-05 0.0022578125 1.366302e-05 0.0032578125 1.3667e-05 0.0032578125 1.366702e-05 0.0027578125 1.3671e-05 0.0027578125 1.367102e-05 0.0007578125 1.3675e-05 0.0007578125 \
1.367502e-05 0.0002578125 1.3679e-05 0.0002578125 1.367902e-05 0.0015078125 1.3683e-05 0.0015078125 1.368302e-05 0.0020078125 1.3687e-05 0.0020078125 1.368702e-05 0.0012578125 1.3691e-05 0.0012578125 1.369102e-05 0.0015078125 1.3695e-05 0.0015078125 1.369502e-05 0.0032578125 1.3699e-05 0.0032578125 \
1.369902e-05 0.0002578125 1.3703e-05 0.0002578125 1.370302e-05 0.0027578125 1.3707e-05 0.0027578125 1.370702e-05 0.0007578125 1.3711e-05 0.0007578125 1.371102e-05 0.0022578125 1.3715e-05 0.0022578125 1.371502e-05 0.0017578125 1.3719e-05 0.0017578125 1.371902e-05 0.0020078125 1.3723e-05 0.0020078125 \
1.372302e-05 0.0012578125 1.3727e-05 0.0012578125 1.372702e-05 0.0012578125 1.3731e-05 0.0012578125 1.373102e-05 0.0022578125 1.3735e-05 0.0022578125 1.373502e-05 0.0002578125 1.3739e-05 0.0002578125 1.373902e-05 0.0032578125 1.3743e-05 0.0032578125 1.374302e-05 0.0027578125 1.3747e-05 0.0027578125 \
1.374702e-05 0.0015078125 1.3751e-05 0.0015078125 1.375102e-05 0.0007578125 1.3755e-05 0.0007578125 1.375502e-05 0.0020078125 1.3759e-05 0.0020078125 1.375902e-05 0.0017578125 1.3763e-05 0.0017578125 1.376302e-05 0.0007578125 1.3767e-05 0.0007578125 1.376702e-05 0.0027578125 1.3771e-05 0.0027578125 \
1.377102e-05 0.0032578125 1.3775e-05 0.0032578125 1.377502e-05 0.0002578125 1.3779e-05 0.0002578125 1.377902e-05 0.0020078125 1.3783e-05 0.0020078125 1.378302e-05 0.0017578125 1.3787e-05 0.0017578125 1.378702e-05 0.0015078125 1.3791e-05 0.0015078125 1.379102e-05 0.0022578125 1.3795e-05 0.0022578125 \
1.379502e-05 0.0012578125 1.3799e-05 0.0012578125 1.379902e-05 0.0032578125 1.3803e-05 0.0032578125 1.380302e-05 0.0007578125 1.3807e-05 0.0007578125 1.380702e-05 0.0002578125 1.3811e-05 0.0002578125 1.381102e-05 0.0012578125 1.3815e-05 0.0012578125 1.381502e-05 0.0027578125 1.3819e-05 0.0027578125 \
1.381902e-05 0.0015078125 1.3823e-05 0.0015078125 1.382302e-05 0.0017578125 1.3827e-05 0.0017578125 1.382702e-05 0.0022578125 1.3831e-05 0.0022578125 1.383102e-05 0.0020078125 1.3835e-05 0.0020078125 1.383502e-05 0.0032578125 1.3839e-05 0.0032578125 1.383902e-05 0.0027578125 1.3843e-05 0.0027578125 \
1.384302e-05 0.0015078125 1.3847e-05 0.0015078125 1.384702e-05 0.0022578125 1.3851e-05 0.0022578125 1.385102e-05 0.0007578125 1.3855e-05 0.0007578125 1.385502e-05 0.0002578125 1.3859e-05 0.0002578125 1.385902e-05 0.0017578125 1.3863e-05 0.0017578125 1.386302e-05 0.0020078125 1.3867e-05 0.0020078125 \
1.386702e-05 0.0012578125 1.3871e-05 0.0012578125 1.387102e-05 0.0002578125 1.3875e-05 0.0002578125 1.387502e-05 0.0017578125 1.3879e-05 0.0017578125 1.387902e-05 0.0032578125 1.3883e-05 0.0032578125 1.388302e-05 0.0015078125 1.3887e-05 0.0015078125 1.388702e-05 0.0020078125 1.3891e-05 0.0020078125 \
1.389102e-05 0.0012578125 1.3895e-05 0.0012578125 1.389502e-05 0.0022578125 1.3899e-05 0.0022578125 1.389902e-05 0.0027578125 1.3903e-05 0.0027578125 1.390302e-05 0.0007578125 1.3907e-05 0.0007578125 1.390702e-05 0.0007578125 1.3911e-05 0.0007578125 1.391102e-05 0.0027578125 1.3915e-05 0.0027578125 \
1.391502e-05 0.0012578125 1.3919e-05 0.0012578125 1.391902e-05 0.0032578125 1.3923e-05 0.0032578125 1.392302e-05 0.0015078125 1.3927e-05 0.0015078125 1.392702e-05 0.0017578125 1.3931e-05 0.0017578125 1.393102e-05 0.0020078125 1.3935e-05 0.0020078125 1.393502e-05 0.0022578125 1.3939e-05 0.0022578125 \
1.393902e-05 0.0002578125]
I_bias (Bias VDD 0) SAR_BIAS
I_cmp (Vp Vn ClkC Outp Outn Valid Bias VDD 0) SAR_CMP
CLp (Outp 0) capacitor c=20f
CLn (Outn 0) capacitor c=20f
CLv (Valid 0) capacitor c=50f
simulatorOptions options temp=@TEMP@
tran tran stop=1.3944e-05 noisefmin=1 noisefmax=50G noiseseed=1
saveOptions options save=selected
save ClkC Outp Outn Valid Bias VDD_SRC:p
