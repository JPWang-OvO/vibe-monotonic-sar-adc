simulator lang=spectre
include "../../../../../blocks/passive/RC_LOWPASS/schematic/netlist.scs"
XRC (IN OUT 0) RC_LOWPASS
VIN (IN 0) vsource type=pulse val0=0 val1=1 delay=1n rise=10p fall=10p width=100n period=200n mag=1
simulatorOptions options temp=25 reltol=1e-5 vabstol=1e-7 iabstol=1e-12
ac ac start=1M stop=1G dec=20
tran tran stop=8n maxstep=10p errpreset=conservative
save IN OUT
