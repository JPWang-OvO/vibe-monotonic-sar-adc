simulator lang=spectre
include "../../../../../systems/counter_demo/COUNTER_DEMO/spectre/netlist.scs"
include "../../../../../support/stimulus/COUNTER_STIM/spectre/netlist.scs"
VDD_SRC (VDD 0) vsource dc=0.9
XSTIM (CLK RST EN VDD 0) COUNTER_STIM
XDUT (CLK RST EN Q\<1\> Q\<0\> VDD 0) COUNTER_DEMO
CL1 (Q\<1\> 0) capacitor c=5f
CL0 (Q\<0\> 0) capacitor c=5f
simulatorOptions options temp=25 reltol=1e-5 vabstol=1e-7 iabstol=1e-12
tran tran stop=20n maxstep=10p errpreset=conservative
save CLK RST EN Q\<1\> Q\<0\>
